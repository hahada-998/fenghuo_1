| IBIS Models Generator: Lattice Diamond (64-bit) 3.14.0.75.2
| Generate date: Fri Oct 31 16:47:50 2025
| IBIS File LibisMaker.ibs
| LibisGen v2.0.1.0, 02/25/2008, Lattice Semiconductor Corporation
| Modified by LibisMaker v2.0.1.0, 02/25/2008, Lattice Semiconductor
| North Carolina State University, ERL, 2006
[IBIS ver]   3.2
[File Name]   BP_4S104G5_impl1.ibs
[File Rev]   2.3
[Date]   Mon Aug  7 08:49:22 PDT 2023
[Source]   Lattice Semiconductor cs200fl Process
   LCMXO3LF-6900C   FINAL
   Lattice Semiconductor has worked hard to ensure the
   models below are accurate and complete.  However, the
   data below was generated using simulation of the
   input/output model files for the silicon.  Therefore,
   the data below is for reference and initial design
   purposes only.
   Lattice Semiconductor grants permission to use this
   data for use in printed circuit design using this
   Lattice programmable logic device.  Other use of this
   code, including the selling or duplication of any
   portion is strictly prohibited.
|   NAMING CONVENTION
   The IBIS [Model] header is limited by the specification to a
   total of characters.  With such a set of characters available
   for naming models it becomes important to attempt to
   meaningfully encode the IO standards so they fit within the
   twenty character limit.  It would seem that twenty characters
   would provide room enough for describing IO's.  However, the
   PLD IO structure continues to grow more and more complex.  The
   complexity is making the twenty characters insuffiently
   descriptive.  In order to overcome this issue the naming
   convention described below is implemented to resolve the issue.
The twenty character space is managed as follows:
   bbbvvvsdddprugtcoixx
   b = standard
   v = voltage (x.xx V)
   s = slew code
   d = drive (xx.x ma)
   p = pullup code
   r = series resistance  or bank_vccio code
   u = terminate to vcc code
   g = terminate to gnd code
   t = terminate to vtt code
   c = common mode termination mode
   o = diff resistor code
   i = diff resistor current code
   x = reserved
   standard
   LVCMOS   lvc
   lvcmosd   lvd
   lvcmosr   lvr
   LVDS25E   lve
   LVTTL   lvt
   lvttld   ltd
   PCI   pci
   pcix   pcx
   lvds25   lvs
   blvds25   blv
   blvds25e   blv
   mlvds25   mlv
   mlvds25e   mlv
   lvpecl33   lvp
   lvpecl33e   lvp
   cml   cml
   hypt   hyp
   rsds25   rsd
   rsds25e   rse
   mipi_lp   mip
   mipi   mip
   vref1   vr1
   vref2   vr2
   ref_res   rer
   slew
   na   a
   fast   f
   slow   s
   pullmode
   off   a
   pullup   b
   pulldown   c
   bushold   d
   clamp   e
   up_clamp   f
   down_clamp   g
   keeper_clamp   h
   impedance or Bank_vccio
   off   a
   25   b
   33   c
   50   d
   100   e
   3.3   f
   2.5   g
   1.8   h
   1.5   i
   1.2   j
   termVCC
   off   a
   50   b
   100   c
   120   d
   termGND
   off   a
   50   b
   100   c
   120   d
   termVTT
   off   a
   60   b
   75   c
   120   d
   150   e
   210   f
   VCMT
   off   a
   VCMT   b
   VTT   c
   DDR-2   d
   differential resistor
   off   a
   100   b
   diff drive
   NA   a
   2.0   b
   3.5   c
   1.25   f
   2.5   g
   Reserved   IO type
   in   input only
   ou   output
   io   I/O
   od   Open drain
   on   Inverting differential I/O
   (signal name only)
   op   Non-Inverting differential I/O
   (signal name only)
   Lattice Semiconductor Corporation
   5555 NE Moore Court
   Hillsboro, OR 97214
   U.S.A
   TEL: 1-800-Lattice (USA and Canada)
   408-826-6000 (other locations)
   web: http://www.latticesemi.com/
   email: techsupport@latticesemi.com
[Disclaimer] This IBIS source code is intended as a design reference
   which illustrates how the Lattice Semiconductor device operates.
   It is the user's responsibility to verify their design for
   consistency and functionality through the use of formal
   verification methods.  Lattice Semiconductor provides no warranty
   regarding the use or functionality of this data.
[Copyright]   Copyright 2007 by Lattice Semiconductor Corporation
|   Component XO3L
[Component]   XO3L
[Manufacturer]   Lattice Semiconductor Corp.
[Package]
|CABGA400
| variable   typ   min   max
R_pkg   355.0m   280.9m   425m
L_pkg   4.66nH   3.57nH   6.4nH
C_pkg   0.64pF   0.39pF   0.85pF
[Pin] signal_name   model_name   R_pin   L_pin   C_pin
W5   i_BASE0_VPP_INT_N_R  lvc330axxxefaaaaaain
A7   i_BASE1_VPP_INT_N_R  lvc330axxxefaaaaaain
B7   i_BASE2_VPP_INT_N_R  lvc330axxxefaaaaaain
D15   i_BASE3_VPP_INT_N_R  lvc330axxxefaaaaaain
T10   i_BMC_SW_UART_TX0_R  lvc330axxxefaaaaaain
B10   i_CPLD1_CLK   lvc330axxxefaaaaaain
A19   i_CPLD1_DONE   lvc330axxxefaaaaaain
C12   i_CPLD1_HDR_R   lvc330axxxefaaaaaain
C17   i_CPLD1_INIT_N   lvc330axxxefaaaaaain
C13   i_CPLD1_JTAGEN   lvc330axxxefaaaaaain
D13   i_CPLD1_PROGRAM_N   lvc330axxxefaaaaaain
Y20   i_CPLD1_PULLUP_SN   lvc330axxxefaaaaaain
R19   i_CT_P1V25_SW0_PG   lvc330axxxefaaaaaain
G9   i_CT_P1V25_SW1_PG   lvc330axxxefaaaaaain
M18   i_CT_P1V25_SW2_PG   lvc330axxxefaaaaaain
K19   i_CT_P1V25_SW3_PG   lvc330axxxefaaaaaain
A11   i_I2C1_CPLD1_REG_SCL lvc330axxxefaaaaaain
U19   i_MB_VPP0_ALT_R_N   lvc330axxxefaaaaaain
J3   i_MB_VPP1_ALT_R_N   lvc330axxxefaaaaaain
J6   i_MB_VPP2_ALT_R_N   lvc330axxxefaaaaaain
H18   i_MB_VPP3_ALT_R_N   lvc330axxxefaaaaaain
R2   i_MCIO01A_ALERT_R_N  lvc330axxxahaaaaaain
J17   i_MCIO01C_ALERT_R_N  lvc330axxxefaaaaaain
P1   i_MCIO11A_ALERT_R_N  lvc330axxxefaaaaaain
L1   i_MCIO11C_ALERT_R_N  lvc330axxxefaaaaaain
M3   i_MCIO21A_ALERT_R_N  lvc330axxxefaaaaaain
F16   i_MCIO21C_ALERT_R_N  lvc330axxxefaaaaaain
V13   i_MCIO31A_ALERT_R_N  lvc330axxxefaaaaaain
F14   i_MCIO31C_ALERT_R_N  lvc330axxxefaaaaaain
A13   i_MCPLD_SGPIO_CLK   lvc330axxxefaaaaaain
B18   i_MCPLD_SGPIO_DATA_OUT lvc330axxxefaaaaaain
A14   i_MCPLD_SGPIO_LD   lvc330axxxefaaaaaain
R8   i_NIC1A_PRSNT0_R_N   lvc330axxxefaaaaaain
Y19   i_NIC1A_PRSNT1_R_N   lvc330axxxefaaaaaain
P10   i_NIC1C_PRSNT0_R_N   lvc330axxxefaaaaaain
W18   i_NIC1C_PRSNT1_R_N   lvc330axxxefaaaaaain
P15   i_NIC1_4_WAKE_R_N   lvc330axxxefaaaaaain
T6   i_NIC2A_PRSNT0_R_N   lvc330axxxefaaaaaain
W20   i_NIC2A_PRSNT1_R_N   lvc330axxxefaaaaaain
T9   i_NIC2C_PRSNT0_R_N   lvc330axxxefaaaaaain
W19   i_NIC2C_PRSNT1_R_N   lvc330axxxefaaaaaain
R14   i_NIC3A_PRSNT0_R_N   lvc330axxxefaaaaaain
N14   i_NIC3A_PRSNT1_R_N   lvc330axxxefaaaaaain
P9   i_NIC3C_PRSNT0_R_N   lvc330axxxefaaaaaain
P16   i_NIC3C_PRSNT1_R_N   lvc330axxxefaaaaaain
U5   i_NIC4A_PRSNT0_R_N   lvc330axxxahaaaaaain
P18   i_NIC4A_PRSNT1_R_N   lvc330axxxefaaaaaain
U4   i_NIC4C_PRSNT0_R_N   lvc330axxxahaaaaaain
N20   i_NIC4C_PRSNT1_R_N   lvc330axxxefaaaaaain
B1   i_NIC5A_PRSNT0_R_N   lvc330axxxefaaaaaain
K6   i_NIC5A_PRSNT1_R_N   lvc330axxxefaaaaaain
F2   i_NIC5C_PRSNT0_R_N   lvc330axxxefaaaaaain
E3   i_NIC5C_PRSNT1_R_N   lvc330axxxefaaaaaain
P8   i_NIC5_8_WAKE_R_N   lvc330axxxefaaaaaain
M7   i_NIC6A_PRSNT0_R_N   lvc330axxxahaaaaaain
M14   i_NIC6A_PRSNT1_R_N   lvc330axxxefaaaaaain
D1   i_NIC6C_PRSNT0_R_N   lvc330axxxefaaaaaain
J5   i_NIC6C_PRSNT1_R_N   lvc330axxxefaaaaaain
N15   i_NIC7A_PRSNT0_R_N   lvc330axxxefaaaaaain
N17   i_NIC7A_PRSNT1_R_N   lvc330axxxefaaaaaain
K17   i_NIC7C_PRSNT0_R_N   lvc330axxxefaaaaaain
V16   i_NIC7C_PRSNT1_R_N   lvc330axxxefaaaaaain
M6   i_NIC8A_PRSNT0_R_N   lvc330axxxahaaaaaain
N5   i_NIC8A_PRSNT1_R_N   lvc330axxxahaaaaaain
V1   i_NIC8C_PRSNT0_R_N   lvc330axxxahaaaaaain
N16   i_NIC8C_PRSNT1_R_N   lvc330axxxefaaaaaain
T11   i_NPU1_4_WAKE_R_N   lvc330axxxefaaaaaain
H19   i_NPU5_8_WAKE_R_N   lvc330axxxefaaaaaain
L16   i_NVME1_ALERT_R_N   lvc330axxxefaaaaaain
U15   i_NVME1_PRSNT0_R_N   lvc330axxxefaaaaaain
L17   i_NVME1_PRSNT1_R_N   lvc330axxxefaaaaaain
L4   i_NVME2_ALERT_R_N   lvc330axxxefaaaaaain
J4   i_NVME2_PRSNT0_R_N   lvc330axxxefaaaaaain
L3   i_NVME2_PRSNT1_R_N   lvc330axxxefaaaaaain
E15   i_NVME3_ALERT_R_N   lvc330axxxefaaaaaain
G14   i_NVME4_ALERT_R_N   lvc330axxxefaaaaaain
J16   i_P0V8_SW0_ALERT_N   lvc330axxxefaaaaaain
V12   i_P0V8_SW0_FAULT_N   lvc330axxxefaaaaaain
T16   i_P0V8_SW0_PWRGD   lvc330axxxefaaaaaain
V14   i_P0V8_SW0_VRHOT_N   lvc330axxxefaaaaaain
H3   i_P0V8_SW1_PWRGD   lvc330axxxefaaaaaain
H4   i_P0V8_SW1_VRHOT_N   lvc330axxxefaaaaaain
J14   i_P0V8_SW2_ALERT_N   lvc330axxxefaaaaaain
F13   i_P0V8_SW2_FAULT_N   lvc330axxxefaaaaaain
A10   i_P0V8_SW2_PWRGD   lvc330axxxefaaaaaain
H14   i_P0V8_SW2_VRHOT_N   lvc330axxxefaaaaaain
F15   i_P0V8_SW3_ALERT_N   lvc330axxxefaaaaaain
G17   i_P0V8_SW3_FAULT_N   lvc330axxxefaaaaaain
F17   i_P0V8_SW3_PWRGD   lvc330axxxefaaaaaain
G16   i_P0V8_SW3_VRHOT_N   lvc330axxxefaaaaaain
Y3   i_P12V_SNS_ALERT   lvc330axxxefaaaaaain
T13   i_P3V3_STBY_PG   lvc330axxxefaaaaaain
T4   i_PAL_P12V_OC   lvc330axxxahaaaaaain
R7   i_PAL_P12V_PG   lvc330axxxefaaaaaain
U14   i_PAL_P12V_STBY_FLTB lvc330axxxefaaaaaain
U17   i_PAL_P12V_STBY_PG   lvc330axxxefaaaaaain
W12   i_PAL_SW_GPU_PRSNT_R_N lvc330axxxefaaaaaain
Y12   i_PAL_SW_PWR_PG   lvc330axxxefaaaaaain
T17   i_PG_P1V8_PLL_R   lvc330axxxefaaaaaain
T18   i_PG_P1V8_R   lvc330axxxefaaaaaain
U2   i_PG_P5V0_R   lvc330axxxahaaaaaain
W15   i_SPI_RESET_R_N   lvc330axxxefaaaaaain
W10   i_SW0_CLKREQ_N_R   lvc330axxxefaaaaaain
Y15   i_SW0_NIC_ALERT_R_N  lvc330axxxefaaaaaain
P14   i_SW0_SDB_TX_R   lvc330axxxefaaaaaain
Y8   i_SW0_UART_TX_R   lvc330axxxefaaaaaain
H2   i_SW1_CLKREQ_N_R   lvc330axxxefaaaaaain
Y4   i_SW1_NIC_ALERT_R_N  lvc330axxxefaaaaaain
C14   i_SW1_SDB_TX_R   lvc330axxxefaaaaaain
A9   i_SW1_UART_TX_R   lvc330axxxefaaaaaain
D5   i_SW2_CLKREQ_N_R   lvc330axxxefaaaaaain
A6   i_SW2_NIC_ALERT_R_N  lvc330axxxefaaaaaain
D17   i_SW2_SDB_TX_R   lvc330axxxefaaaaaain
B6   i_SW2_UART_TX_R   lvc330axxxefaaaaaain
B2   i_SW3_CLKREQ_N_R   lvc330axxxefaaaaaain
D7   i_SW3_NIC_ALERT_R_N  lvc330axxxefaaaaaain
A20   i_SW3_SDB_TX_R   lvc330axxxefaaaaaain
B20   i_SW3_UART_TX_R   lvc330axxxefaaaaaain
G1   i_TEMP_ALERT_0_R   lvc330axxxefaaaaaain
B16   i_TEMP_ALERT_1_R   lvc330axxxefaaaaaain
B11   i_TEMP_ALERT_2_R   lvc330axxxefaaaaaain
R6   i_TEMP_ALERT_3_R   lvc330axxxefaaaaaain
A12   io_I2C1_CPLD1_REG_SDA lvc330s080eaaaaaaaio
C11   io_I2C1_CPLD1_UPDATE_SCL lvc330s080eaaaaaaaio
D11   io_I2C1_CPLD1_UPDATE_SDA lvc330s080eaaaaaaaio
Y11   o_BMC_SW_UART_RX0_R  lvc330s080aaaaaaaaou
W3   o_CPLD1_LED0_N   lvc330s080aaaaaaaaou
Y2   o_CPLD1_LED1_N   lvc330s080aaaaaaaaou
B13   o_CPLD_RSV1   lvc330s080aaaaaaaaou
A17   o_CPLD_RSV2   lvc330s080aaaaaaaaou
B12   o_CPLD_RSV3   lvc330s080aaaaaaaaou
B14   o_CPLD_RSV4   lvc330s080aaaaaaaaou
A18   o_CPLD_RSV5   lvc330s080aaaaaaaaou
B17   o_CPLD_RSV6   lvc330s080aaaaaaaaou
W7   o_CT_P1V25_SW_EN_R   lvc330s080aaaaaaaaou
A8   o_I2C_RST0_R_N   lvc330s080aaaaaaaaou
C8   o_I2C_RST1_R_N   lvc330s080aaaaaaaaou
W6   o_I2C_RST2_R_N   lvc330s080aaaaaaaaou
C6   o_I2C_RST3_R_N   lvc330s080aaaaaaaaou
Y17   o_I2C_RST4_7_R_N   lvc330s080aaaaaaaaou
M16   o_MCIO01A_CB_RSV_R   lvc330s080aaaaaaaaou
U18   o_MCIO01A_PE_RST_R_N lvc330s080aaaaaaaaou
L15   o_MCIO01C_CB_RSV_R   lvc330s080aaaaaaaaou
W2   o_MCIO01C_PE_RST_R_N lvc330s080aaaaaaaaou
R4   o_MCIO02A_CB_RSV_R   lvc330s120ahaaaaaaod
Y1   o_MCIO02A_PE_RST_R_N lvc330s080aaaaaaaaou
H17   o_MCIO02C_CB_RSV_R   lvc330s080aaaaaaaaou
K4   o_MCIO11A_CB_RSV_R   lvc330s080aaaaaaaaou
K2   o_MCIO11A_PE_RST_R_N lvc330s080aaaaaaaaou
K1   o_MCIO11C_CB_RSV_R   lvc330s080aaaaaaaaou
N3   o_MCIO11C_PE_RST_R_N lvc330s120ahaaaaaaod
P3   o_MCIO12A_CB_RSV_R   lvc330s120ahaaaaaaod
T2   o_MCIO12A_PE_RST_R_N lvc330s120ahaaaaaaod
M2   o_MCIO12C_CB_RSV_R   lvc330s080aaaaaaaaou
K7   o_MCIO21A_CB_RSV_R   lvc330s080aaaaaaaaou
H7   o_MCIO21A_PE_RST_R_N lvc330s080aaaaaaaaou
L7   o_MCIO21C_CB_RSV_R   lvc330s080aaaaaaaaou
D8   o_MCIO21C_PE_RST_R_N lvc330s080aaaaaaaaou
P2   o_MCIO22A_CB_RSV_R   lvc330s080aaaaaaaaou
N2   o_MCIO22A_PE_RST_R_N lvc330s080aaaaaaaaou
G15   o_MCIO22C_CB_RSV_R   lvc330s080aaaaaaaaou
J18   o_MCIO31A_CB_RSV_R   lvc330s080aaaaaaaaou
M20   o_MCIO31A_PE_RST_R_N lvc330s080aaaaaaaaou
K20   o_MCIO31C_CB_RSV_R   lvc330s080aaaaaaaaou
K16   o_MCIO31C_PE_RST_R_N lvc330s080aaaaaaaaou
V19   o_MCIO32A_CB_RSV_R   lvc330s080aaaaaaaaou
M17   o_MCIO32A_PE_RST_R_N lvc330s080aaaaaaaaou
J15   o_MCIO32C_CB_RSV_R   lvc330s080aaaaaaaaou
A16   o_MCPLD_SGPIO_DATA_IN lvc330s080aaaaaaaaou
R16   o_NIC1A_POWER_EN_R   lvc330s080aaaaaaaaou
R15   o_NIC1A_RST_R_N   lvc330s080aaaaaaaaou
Y18   o_NIC1A_RSV_R   lvc330s080aaaaaaaaou
T14   o_NIC1C_POWER_EN_R   lvc330s080aaaaaaaaou
R11   o_NIC1C_RST_R_N   lvc330s080aaaaaaaaou
W17   o_NIC1C_RSV_R   lvc330s080aaaaaaaaou
R13   o_NIC2A_POWER_EN_R   lvc330s080aaaaaaaaou
P11   o_NIC2A_RST_R_N   lvc330s080aaaaaaaaou
V20   o_NIC2A_RSV_R   lvc330s080aaaaaaaaou
R12   o_NIC2C_POWER_EN_R   lvc330s080aaaaaaaaou
R10   o_NIC2C_RST_R_N   lvc330s080aaaaaaaaou
T19   o_NIC2C_RSV_R   lvc330s080aaaaaaaaou
W1   o_NIC3A_POWER_EN_R   lvc330s080aaaaaaaaou
P13   o_NIC3A_RST_R_N   lvc330s080aaaaaaaaou
U12   o_NIC3A_RSV_R   lvc330s080aaaaaaaaou
P12   o_NIC3C_POWER_EN_R   lvc330s080aaaaaaaaou
U9   o_NIC3C_RST_R_N   lvc330s080aaaaaaaaou
R17   o_NIC3C_RSV_R   lvc330s080aaaaaaaaou
T8   o_NIC4A_POWER_EN_R   lvc330s080aaaaaaaaou
U6   o_NIC4A_RST_R_N   lvc330s080aaaaaaaaou
N19   o_NIC4A_RSV_R   lvc330s080aaaaaaaaou
T7   o_NIC4C_POWER_EN_R   lvc330s080aaaaaaaaou
T3   o_NIC4C_RST_R_N   lvc330s120ahaaaaaaod
P20   o_NIC4C_RSV_R   lvc330s080aaaaaaaaou
D2   o_NIC5A_POWER_EN_R   lvc330s080aaaaaaaaou
F7   o_NIC5A_RST_R_N   lvc330s080aaaaaaaaou
K5   o_NIC5A_RSV_R   lvc330s080aaaaaaaaou
G6   o_NIC5C_POWER_EN_R   lvc330s080aaaaaaaaou
E1   o_NIC5C_RST_R_N   lvc330s080aaaaaaaaou
H6   o_NIC5C_RSV_R   lvc330s080aaaaaaaaou
P7   o_NIC6A_POWER_EN_R   lvc330s080aaaaaaaaou
P6   o_NIC6A_RST_R_N   lvc330s120ahaaaaaaod
R9   o_NIC6A_RSV_R   lvc330s080aaaaaaaaou
L5   o_NIC6C_POWER_EN_R   lvc330s080aaaaaaaaou
G5   o_NIC6C_RST_R_N   lvc330s080aaaaaaaaou
C1   o_NIC6C_RSV_R   lvc330s080aaaaaaaaou
M15   o_NIC7A_POWER_EN_R   lvc330s080aaaaaaaaou
L14   o_NIC7A_RST_R_N   lvc330s080aaaaaaaaou
V17   o_NIC7A_RSV_R   lvc330s080aaaaaaaaou
R3   o_NIC7C_POWER_EN_R   lvc330s120ahaaaaaaod
V10   o_NIC7C_RST_R_N   lvc330s080aaaaaaaaou
P17   o_NIC7C_RSV_R   lvc330s080aaaaaaaaou
C2   o_NIC8A_POWER_EN_R   lvc330s080aaaaaaaaou
L6   o_NIC8A_RST_R_N   lvc330s080aaaaaaaaou
M5   o_NIC8A_RSV_R   lvc330s080aaaaaaaaou
R1   o_NIC8C_POWER_EN_R   lvc330s120ahaaaaaaod
V9   o_NIC8C_RST_R_N   lvc330s080aaaaaaaaou
V15   o_NIC8C_RSV_R   lvc330s080aaaaaaaaou
U1   o_NPU1A_POWER_EN_R   lvc330s120ahaaaaaaod
P19   o_NPU1A_RST_R_N   lvc330s080aaaaaaaaou
R20   o_NPU1A_RSV_R   lvc330s080aaaaaaaaou
T1   o_NPU1C_POWER_EN_R   lvc330s120ahaaaaaaod
T20   o_NPU1C_RST_R_N   lvc330s080aaaaaaaaou
R5   o_NPU1C_RSV_R   lvc330s120ahaaaaaaod
V4   o_NPU2A_POWER_EN_R   lvc330s120ahaaaaaaod
V3   o_NPU2A_RST_R_N   lvc330s120ahaaaaaaod
V2   o_NPU2A_RSV_R   lvc330s120ahaaaaaaod
U10   o_NPU2C_POWER_EN_R   lvc330s080aaaaaaaaou
V8   o_NPU2C_RST_R_N   lvc330s080aaaaaaaaou
V6   o_NPU2C_RSV_R   lvc330s080aaaaaaaaou
F8   o_NPU3A_POWER_EN_R   lvc330s080aaaaaaaaou
E2   o_NPU3A_RST_R_N   lvc330s080aaaaaaaaou
E7   o_NPU3A_RSV_R   lvc330s080aaaaaaaaou
G12   o_NPU3C_POWER_EN_R   lvc330s080aaaaaaaaou
F4   o_NPU3C_RST_R_N   lvc330s080aaaaaaaaou
G11   o_NPU3C_RSV_R   lvc330s080aaaaaaaaou
G10   o_NPU4A_POWER_EN_R   lvc330s080aaaaaaaaou
F3   o_NPU4A_RST_R_N   lvc330s080aaaaaaaaou
F6   o_NPU4A_RSV_R   lvc330s080aaaaaaaaou
E6   o_NPU4C_POWER_EN_R   lvc330s080aaaaaaaaou
G4   o_NPU4C_RST_R_N   lvc330s080aaaaaaaaou
F5   o_NPU4C_RSV_R   lvc330s080aaaaaaaaou
F12   o_NPU5A_POWER_EN_R   lvc330s080aaaaaaaaou
D18   o_NPU5A_RST_R_N   lvc330s080aaaaaaaaou
F19   o_NPU5A_RSV_R   lvc330s080aaaaaaaaou
N6   o_NPU5C_POWER_EN_R   lvc330s120ahaaaaaaod
G7   o_NPU5C_RST_R_N   lvc330s080aaaaaaaaou
P5   o_NPU5C_RSV_R   lvc330s120ahaaaaaaod
D16   o_NPU6A_POWER_EN_R   lvc330s080aaaaaaaaou
G8   o_NPU6A_RST_R_N   lvc330s080aaaaaaaaou
G19   o_NPU6A_RSV_R   lvc330s080aaaaaaaaou
C19   o_NPU6C_POWER_EN_R   lvc330s080aaaaaaaaou
G13   o_NPU6C_RST_R_N   lvc330s080aaaaaaaaou
J19   o_NPU6C_RSV_R   lvc330s080aaaaaaaaou
M19   o_NPU7A_POWER_EN_R   lvc330s080aaaaaaaaou
N18   o_NPU7A_RST_R_N   lvc330s080aaaaaaaaou
E20   o_NPU7A_RSV_R   lvc330s080aaaaaaaaou
G20   o_NPU7C_POWER_EN_R   lvc330s080aaaaaaaaou
F20   o_NPU7C_RST_R_N   lvc330s080aaaaaaaaou
H20   o_NPU7C_RSV_R   lvc330s080aaaaaaaaou
L19   o_NPU8A_POWER_EN_R   lvc330s080aaaaaaaaou
E19   o_NPU8A_RST_R_N   lvc330s080aaaaaaaaou
L20   o_NPU8A_RSV_R   lvc330s080aaaaaaaaou
F18   o_NPU8C_POWER_EN_R   lvc330s080aaaaaaaaou
E17   o_NPU8C_RST_R_N   lvc330s080aaaaaaaaou
D19   o_NPU8C_RSV_R   lvc330s080aaaaaaaaou
U20   o_NVME1_POWER_EN_R   lvc330s080aaaaaaaaou
K18   o_NVME1_RST_R_N   lvc330s080aaaaaaaaou
H16   o_NVME1_RSV_R   lvc330s080aaaaaaaaou
M1   o_NVME2_POWER_EN_R   lvc330s080aaaaaaaaou
L2   o_NVME2_RST_R_N   lvc330s080aaaaaaaaou
N1   o_NVME2_RSV_R   lvc330s080aaaaaaaaou
D12   o_NVME3_POWER_EN_R   lvc330s080aaaaaaaaou
E14   o_NVME3_RST_R_N   lvc330s080aaaaaaaaou
F11   o_NVME3_RSV_R   lvc330s080aaaaaaaaou
K14   o_NVME4_POWER_EN_R   lvc330s080aaaaaaaaou
K15   o_NVME4_RST_R_N   lvc330s080aaaaaaaaou
H15   o_NVME4_RSV_R   lvc330s080aaaaaaaaou
F10   o_P0V8_SW_EN_R   lvc330s080aaaaaaaaou
W16   o_P1V8_EN_R   lvc330s080aaaaaaaaou
Y16   o_P1V8_PLL_EN_R   lvc330s080aaaaaaaaou
Y5   o_P5V0_EN_R   lvc330s080aaaaaaaaou
W8   o_PAL_DB2000_PWRGD0  lvc330s080aaaaaaaaou
G2   o_PAL_DB2000_PWRGD1  lvc330s080aaaaaaaaou
A2   o_PAL_DB2000_PWRGD2  lvc330s080aaaaaaaaou
B9   o_PAL_DB2000_PWRGD3  lvc330s080aaaaaaaaou
Y14   o_PAL_P12V_EN_R   lvc330s080aaaaaaaaou
Y13   o_PAL_RST_SW0_3_NIC_VPP1_N_R lvc330s080aaaaaaaaou
Y7   o_PAL_RST_SW0_VPP2_N_R lvc330s080aaaaaaaaou
F1   o_PAL_RST_SW1_VPP2_N_R lvc330s080aaaaaaaaou
P4   o_PAL_RST_SW2_VPP2_N_R lvc330s120ahaaaaaaod
D6   o_PAL_RST_SW3_VPP2_N_R lvc330s080aaaaaaaaou
B3   o_PAL_SPI_CSCLK_S0_R lvc330s080aaaaaaaaou
B5   o_PAL_SPI_CSCLK_S1_R lvc330s080aaaaaaaaou
A3   o_PAL_SPI_MISOMOSI_S0_R lvc330s080aaaaaaaaou
C4   o_PAL_SPI_MISOMOSI_S1_R lvc330s080aaaaaaaaou
D10   o_PAL_SW0_3_VPP_S0_R lvc330s080aaaaaaaaou
D14   o_PAL_SW0_3_VPP_S1_R lvc330s080aaaaaaaaou
T5   o_PAL_SW_PWR_EN_R   lvc330s120ahaaaaaaod
W9   o_SW0_MCIO2_CLK_OE_N_R lvc330s080aaaaaaaaou
Y9   o_SW0_NPU_CLK_OE_N_R lvc330s080aaaaaaaaou
Y10   o_SW0_PAL_SPI_SEL_R  lvc330s080aaaaaaaaou
W13   o_SW0_PEX_PERST_R_N  lvc330s080aaaaaaaaou
T12   o_SW0_SDB_RX_R   lvc330s080aaaaaaaaou
W14   o_SW0_SPI_CS_SEL_R   lvc330s080aaaaaaaaou
W4   o_SW0_UART_RX_R   lvc330s080aaaaaaaaou
J2   o_SW1_MCIO2_CLK_OE_N_R lvc330s080aaaaaaaaou
H1   o_SW1_NPU_CLK_OE_N_R lvc330s080aaaaaaaaou
A5   o_SW1_PAL_SPI_SEL_R  lvc330s080aaaaaaaaou
J1   o_SW1_PEX_PERST_R_N  lvc330s080aaaaaaaaou
C15   o_SW1_SDB_RX_R   lvc330s080aaaaaaaaou
A4   o_SW1_SPI_CS_SEL_R   lvc330s080aaaaaaaaou
C3   o_SW1_UART_RX_R   lvc330s080aaaaaaaaou
B4   o_SW2_MCIO2_CLK_OE_N_R lvc330s080aaaaaaaaou
A1   o_SW2_NPU_CLK_OE_N_R lvc330s080aaaaaaaaou
G3   o_SW2_PAL_SPI_SEL_R  lvc330s080aaaaaaaaou
E4   o_SW2_PEX_PERST_R_N  lvc330s080aaaaaaaaou
C18   o_SW2_SDB_RX_R   lvc330s080aaaaaaaaou
M4   o_SW2_SPI_CS_SEL_R   lvc330s080aaaaaaaaou
N4   o_SW2_UART_RX_R   lvc330s120ahaaaaaaod
B8   o_SW3_MCIO2_CLK_OE_N_R lvc330s080aaaaaaaaou
C10   o_SW3_NPU_CLK_OE_N_R lvc330s080aaaaaaaaou
C20   o_SW3_PAL_SPI_SEL_R  lvc330s080aaaaaaaaou
F9   o_SW3_PEX_PERST_R_N  lvc330s080aaaaaaaaou
B19   o_SW3_SDB_RX_R   lvc330s080aaaaaaaaou
D20   o_SW3_SPI_CS_SEL_R   lvc330s080aaaaaaaaou
C16   o_SW3_UART_RX_R   lvc330s080aaaaaaaaou
| Models and submodels in the file (5): lvc330axxxahaaaaaain (Input), lvc330axxxefaaaaaain (Input), lvc330s080aaaaaaaaou (Output), lvc330s080eaaaaaaaio (I/O), lvc330s120ahaaaaaaod (I/O_open_drain)
