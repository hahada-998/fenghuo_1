| IBIS Models Generator: Lattice Diamond (64-bit) 3.14.0.75.2
| Generate date: Wed Oct 29 16:09:52 2025
| IBIS File LibisMaker.ibs
| LibisGen v2.0.1.0, 02/25/2008, Lattice Semiconductor Corporation
| Modified by LibisMaker v2.0.1.0, 02/25/2008, Lattice Semiconductor
| North Carolina State University, ERL, 2006
[IBIS ver]   3.2
[File Name]   BP_4S104G5_S_impl1.ibs
[File Rev]   3.6
[Date]   Thu Aug  3 04:51:03 PDT 2023
[Source]   Lattice Semiconductor cs200fl Process
   LCMXO2-2000HC   FINAL
   Lattice Semiconductor has worked hard to ensure the
   models below are accurate and complete.  However, the
   data below was generated using simulation of the
   input/output model files for the silicon.  Therefore,
   the data below is for reference and initial design
   purposes only.
   Lattice Semiconductor grants permission to use this
   data for use in printed circuit design using this
   Lattice programmable logic device.  Other use of this
   code, including the selling or duplication of any
   portion is strictly prohibited.
|   NAMING CONVENTION
   The IBIS [Model] header is limited by the specification to a
   total of characters.  With such a set of characters available
   for naming models it becomes important to attempt to
   meaningfully encode the IO standards so they fit within the
   twenty character limit.  It would seem that twenty characters
   would provide room enough for describing IO's.  However, the
   PLD IO structure continues to grow more and more complex.  The
   complexity is making the twenty characters insuffiently
   descriptive.  In order to overcome this issue the naming
   convention described below is implemented to resolve the issue.
The twenty character space is managed as follows:
   bbbvvvsdddprugtcoixx
   b = standard
   v = voltage (x.xx V)
   s = slew code
   d = drive (xx.x ma)
   p = pullup code
   r = series resistance  or bank_vccio code
   u = terminate to vcc code
   g = terminate to gnd code
   t = terminate to vtt code
   c = common mode termination mode
   o = diff resistor code
   i = diff resistor current code
   x = reserved
   standard
   lvcmos   lvc
   lvcmosd   lvd
   lvcmosr   lvr
   lvds25e   lve
   lvttl   lvt
   lvttld   ltd
   pci   pci
   sstl_I   ss1
   sstl_II   ss2
   sstld_I   s1d
   sstld_II   s2d
   hstl_i   hs1
   hstl_ii   hs2
   hstld_i   h1d
   hstld_ii   h2d
   lvds25   lvs
   blvds25   blv
   blvds25e   blv
   mlvds25   mlv
   mlvds25e   mlv
   lvpecl33   lvp
   lvpecl33e   lvp
   rsds25   rsd
   rsds25e   rse
   mipi   mip
   mipi_lp   mip
   vref1   vr1
   vref2   vr2
   ref_res   rer
   slew
   na   a
   fast   f
   slow   s
   pullmode
   off   a
   pullup   b
   pulldown   c
   bushold   d
   clamp   e
   up_clamp   f
   down_clamp   g
   keeper_clamp   h
   impedance or Bank_vccio
   off   a
   25   b
   33   c
   50   d
   100   e
   3.3   f
   2.5   g
   1.8   h
   1.5   i
   1.2   j
   termVCC
   off   a
   50   b
   100   c
   120   d
   termGND
   off   a
   50   b
   100   c
   120   d
   termVTT
   off   a
   60   b
   75   c
   120   d
   150   e
   210   f
   VCMT
   off   a
   VCMT   b
   VTT   c
   DDR-2   d
   differential resistor
   off   a
   100   b
   diff drive
   NA   a
   2.0   b
   3.5   c
   1.25   f
   2.5   g
   Reserved   IO type
   in   input only
   ou   output
   io   I/O
   od   Open drain
   on   Inverting differential I/O
   (signal name only)
   op   Non-Inverting differential I/O
   (signal name only)
   Lattice Semiconductor Corporation
   5555 NE Moore Court
   Hillsboro, OR 97214
   U.S.A
   TEL: 1-800-Lattice (USA and Canada)
   408-826-6000 (other locations)
   web: http://www.latticesemi.com/
   email: techsupport@latticesemi.com
[Disclaimer] This IBIS source code is intended as a design reference
   which illustrates how the Lattice Semiconductor device operates.
   It is the user's responsibility to verify their design for
   consistency and functionality through the use of formal
   verification methods.  Lattice Semiconductor provides no warranty
   regarding the use or functionality of this data.
[Copyright]   Copyright 2007 by Lattice Semiconductor Corporation
|   Component XO2
[Component]   XO2
[Manufacturer]   Lattice Semiconductor Corp.
[Package]
|CABGA256
| variable   typ   min   max
 R_pkg   138.8m   126.7m   150m
 L_pkg   5.59nH   3.24nH   8.59nH
 C_pkg   0.281pF   0.275pF   0.288pF
[Pin] signal_name   model_name   R_pin   L_pin   C_pin
F3   i_BOARD_ID0   lvc250axxxggaaaaaain
E2   i_BOARD_ID1   lvc250axxxggaaaaaain
E3   i_BOARD_ID2   lvc250axxxggaaaaaain
F2   i_BOARD_ID3   lvc250axxxggaaaaaain
G2   i_BOARD_ID4   lvc250axxxggaaaaaain
C8   i_CPLD2_CLK   lvc250axxxggaaaaaain
C13   i_CPLD2_DONE   lvc250axxxggaaaaaain
B6   i_CPLD2_HDR_R   lvc250axxxggaaaaaain
A13   i_CPLD2_INIT_N   lvc250axxxggaaaaaain
C10   i_CPLD2_JTAGEN_N   lvc250axxxggaaaaaain
B10   i_CPLD2_PROGRAM_N   lvc250axxxggaaaaaain
R12   i_CPLD2_PULLUP_SN   lvc250axxxggaaaaaain
B9   i_I2C1_CPLD2_REG_SCL lvc250axxxggaaaaaain
T7   i_MCIO01A_CB_ID0_R   lvc250axxxggaaaaaain
R7   i_MCIO01A_CB_ID1_R   lvc250axxxggaaaaaain
M10   i_MCIO01A_NVME0_PRSNT_R_N lvc250axxxggaaaaaain
N9   i_MCIO01A_NVME1_PRSNT_R_N lvc250axxxggaaaaaain
G6   i_MCIO01A_PE_WAKE_R_N lvc250axxxggaaaaaain
T9   i_MCIO01C_CB_ID0_R   lvc250axxxggaaaaaain
T8   i_MCIO01C_CB_ID1_R   lvc250axxxggaaaaaain
F7   i_MCIO01C_NVME0_PRSNT_R_N lvc250axxxggaaaaaain
F4   i_MCIO01C_NVME1_PRSNT_R_N lvc250axxxggaaaaaain
L10   i_MCIO01C_PE_WAKE_R_N lvc250axxxggaaaaaain
T11   i_MCIO02A_CB_ID0_R   lvc250axxxggaaaaaain
T12   i_MCIO02A_CB_ID1_R   lvc250axxxggaaaaaain
T14   i_MCIO02A_NVME0_PRSNT_R_N lvc250axxxggaaaaaain
P16   i_MCIO02A_NVME1_PRSNT_R_N lvc250axxxggaaaaaain
J14   i_MCIO02A_PE_WAKE_R_N lvc250axxxggaaaaaain
T10   i_MCIO02C_CB_ID0_R   lvc250axxxggaaaaaain
R11   i_MCIO02C_CB_ID1_R   lvc250axxxggaaaaaain
K16   i_MCIO02C_NVME0_PRSNT_R_N lvc250axxxggaaaaaain
H14   i_MCIO02C_NVME1_PRSNT_R_N lvc250axxxggaaaaaain
K12   i_MCIO02C_PE_WAKE_R_N lvc250axxxggaaaaaain
R6   i_MCIO11A_CB_ID0_R   lvc250axxxggaaaaaain
T5   i_MCIO11A_CB_ID1_R   lvc250axxxggaaaaaain
N8   i_MCIO11A_NVME0_PRSNT_R_N lvc250axxxggaaaaaain
M8   i_MCIO11A_NVME1_PRSNT_R_N lvc250axxxggaaaaaain
M6   i_MCIO11A_PE_WAKE_R_N lvc250axxxggaaaaaain
R5   i_MCIO11C_CB_ID0_R   lvc250axxxggaaaaaain
T4   i_MCIO11C_CB_ID1_R   lvc250axxxggaaaaaain
L5   i_MCIO11C_NVME0_PRSNT_R_N lvc250axxxggaaaaaain
P5   i_MCIO11C_NVME1_PRSNT_R_N lvc250axxxggaaaaaain
R4   i_MCIO11C_PE_WAKE_R_N lvc250axxxggaaaaaain
T6   i_MCIO12A_CB_ID0_R   lvc250axxxggaaaaaain
R10   i_MCIO12A_CB_ID1_R   lvc250axxxggaaaaaain
J13   i_MCIO12A_NVME0_PRSNT_R_N lvc250axxxggaaaaaain
G5   i_MCIO12A_NVME1_PRSNT_R_N lvc250axxxggaaaaaain
N14   i_MCIO12A_PE_WAKE_R_N lvc250axxxggaaaaaain
R9   i_MCIO12C_CB_ID0_R   lvc250axxxggaaaaaain
R8   i_MCIO12C_CB_ID1_R   lvc250axxxggaaaaaain
L13   i_MCIO12C_NVME0_PRSNT_R_N lvc250axxxggaaaaaain
P13   i_MCIO12C_NVME1_PRSNT_R_N lvc250axxxggaaaaaain
P11   i_MCIO12C_PE_WAKE_R_N lvc250axxxggaaaaaain
F1   i_MCIO21A_CB_ID0_R   lvc250axxxggaaaaaain
G1   i_MCIO21A_CB_ID1_R   lvc250axxxggaaaaaain
J2   i_MCIO21A_NVME0_PRSNT_R_N lvc250axxxggaaaaaain
J3   i_MCIO21A_NVME1_PRSNT_R_N lvc250axxxggaaaaaain
H5   i_MCIO21A_PE_WAKE_R_N lvc250axxxggaaaaaain
D1   i_MCIO21C_CB_ID0_R   lvc250axxxggaaaaaain
E1   i_MCIO21C_CB_ID1_R   lvc250axxxggaaaaaain
H3   i_MCIO21C_NVME0_PRSNT_R_N lvc250axxxggaaaaaain
H4   i_MCIO21C_NVME1_PRSNT_R_N lvc250axxxggaaaaaain
G4   i_MCIO21C_PE_WAKE_R_N lvc250axxxggaaaaaain
L1   i_MCIO22A_CB_ID0_R   lvc250axxxggaaaaaain
K1   i_MCIO22A_CB_ID1_R   lvc250axxxggaaaaaain
R1   i_MCIO22A_NVME0_PRSNT_R_N lvc250axxxggaaaaaain
P1   i_MCIO22A_NVME1_PRSNT_R_N lvc250axxxggaaaaaain
P2   i_MCIO22A_PE_WAKE_R_N lvc250axxxggaaaaaain
J1   i_MCIO22C_CB_ID0_R   lvc250axxxggaaaaaain
H2   i_MCIO22C_CB_ID1_R   lvc250axxxggaaaaaain
N3   i_MCIO22C_NVME0_PRSNT_R_N lvc250axxxggaaaaaain
N2   i_MCIO22C_NVME1_PRSNT_R_N lvc250axxxggaaaaaain
M2   i_MCIO22C_PE_WAKE_R_N lvc250axxxggaaaaaain
B13   i_MCIO31A_CB_ID0_R   lvc250axxxggaaaaaain
A14   i_MCIO31A_CB_ID1_R   lvc250axxxggaaaaaain
D14   i_MCIO31A_NVME0_PRSNT_R_N lvc250axxxggaaaaaain
C12   i_MCIO31A_NVME1_PRSNT_R_N lvc250axxxggaaaaaain
D15   i_MCIO31A_PE_WAKE_R_N lvc250axxxggaaaaaain
B14   i_MCIO31C_CB_ID0_R   lvc250axxxggaaaaaain
A15   i_MCIO31C_CB_ID1_R   lvc250axxxggaaaaaain
E16   i_MCIO31C_NVME0_PRSNT_R_N lvc250axxxggaaaaaain
C15   i_MCIO31C_NVME1_PRSNT_R_N lvc250axxxggaaaaaain
D16   i_MCIO31C_PE_WAKE_R_N lvc250axxxggaaaaaain
B3   i_MCIO32A_CB_ID0_R   lvc250axxxggaaaaaain
B1   i_MCIO32A_CB_ID1_R   lvc250axxxggaaaaaain
C5   i_MCIO32A_NVME0_PRSNT_R_N lvc250axxxggaaaaaain
D6   i_MCIO32A_NVME1_PRSNT_R_N lvc250axxxggaaaaaain
B7   i_MCIO32A_PE_WAKE_R_N lvc250axxxggaaaaaain
A3   i_MCIO32C_CB_ID0_R   lvc250axxxggaaaaaain
B4   i_MCIO32C_CB_ID1_R   lvc250axxxggaaaaaain
D8   i_MCIO32C_NVME0_PRSNT_R_N lvc250axxxggaaaaaain
E8   i_MCIO32C_NVME1_PRSNT_R_N lvc250axxxggaaaaaain
E9   i_MCIO32C_PE_WAKE_R_N lvc250axxxggaaaaaain
K2   i_NVME3_PRSNT0_R_N   lvc250axxxggaaaaaain
K3   i_NVME3_PRSNT1_R_N   lvc250axxxggaaaaaain
B12   i_NVME4_PRSNT0_R_N   lvc250axxxggaaaaaain
A11   i_NVME4_PRSNT1_R_N   lvc250axxxggaaaaaain
N11   i_P0V8_SW1_ALERT_N   lvc250axxxggaaaaaain
P10   i_P0V8_SW1_FAULT_N   lvc250axxxggaaaaaain
A4   i_PCA_ID0   lvc250axxxggaaaaaain
B5   i_PCA_ID1   lvc250axxxggaaaaaain
A5   i_PCA_ID2   lvc250axxxggaaaaaain
D2   i_PCB_ID0   lvc250axxxggaaaaaain
C1   i_PCB_ID1   lvc250axxxggaaaaaain
C2   i_PCB_ID2   lvc250axxxggaaaaaain
A8   i_SCPLD_SGPIO_CLK   lvc250axxxggaaaaaain
D11   i_SCPLD_SGPIO_LD   lvc250axxxggaaaaaain
A10   io_I2C1_CPLD2_REG_SDA lvc250s080gaaaaaaaio
A9   io_I2C1_CPLD2_UPDATE_SCL lvc250s080gaaaaaaaio
C9   io_I2C1_CPLD2_UPDATE_SDA lvc250s080gaaaaaaaio
M9   io_MCIO01A_PWR_EN_R  lvc250s080gaaaaaaaio
F5   io_MCIO01C_PWR_EN_R  lvc250s080gaaaaaaaio
R16   io_MCIO02A_PWR_EN_R  lvc250s080gaaaaaaaio
J16   io_MCIO02C_PWR_EN_R  lvc250s080gaaaaaaaio
M7   io_MCIO11A_PWR_EN_R  lvc250s080gaaaaaaaio
P4   io_MCIO11C_PWR_EN_R  lvc250s080gaaaaaaaio
F8   io_MCIO12A_PWR_EN_R  lvc250s080gaaaaaaaio
M11   io_MCIO12C_PWR_EN_R  lvc250s080gaaaaaaaio
J4   io_MCIO21A_PWR_EN_R  lvc250s080gaaaaaaaio
G3   io_MCIO21C_PWR_EN_R  lvc250s080gaaaaaaaio
N1   io_MCIO22A_PWR_EN_R  lvc250s080gaaaaaaaio
M3   io_MCIO22C_PWR_EN_R  lvc250s080gaaaaaaaio
F16   io_MCIO31A_PWR_EN_R  lvc250s080gaaaaaaaio
C16   io_MCIO31C_PWR_EN_R  lvc250s080gaaaaaaaio
C7   io_MCIO32A_PWR_EN_R  lvc250s080gaaaaaaaio
F9   io_MCIO32C_PWR_EN_R  lvc250s080gaaaaaaaio
P12   o_CPLD2_LED2_N   lvc250s080aaaaaaaaou
T13   o_CPLD2_LED3_N   lvc250s080aaaaaaaaou
L15   o_CPLD_RSV1_R   lvc250s080aaaaaaaaou
E11   o_CPLD_RSV2_R   lvc250s080aaaaaaaaou
L14   o_CPLD_RSV3_R   lvc250s080aaaaaaaaou
G14   o_CPLD_RSV4_R   lvc250s080aaaaaaaaou
G13   o_CPLD_RSV5_R   lvc250s080aaaaaaaaou
J15   o_CPLD_RSV6_R   lvc250s080aaaaaaaaou
P8   o_MCIO01_11_GPU_THROTTLE_R_N lvc250s080caaaaaaaou
T15   o_MCIO02_12_GPU_THROTTLE_R_N lvc250s080caaaaaaaou
B16   o_MCIO21_31_GPU_THROTTLE_R_N lvc250s080caaaaaaaou
M1   o_MCIO22_32_GPU_THROTTLE_R_N lvc250s080caaaaaaaou
K5   o_NIC1_4_GPU_THROTTLE_R_N lvc250s080caaaaaaaou
E15   o_NIC5_8_GPU_THROTTLE_R_N lvc250s080caaaaaaaou
G11   o_NPU1_4_GPU_THROTTLE_R_N lvc250s080caaaaaaaou
L4   o_NPU5_8_GPU_THROTTLE_R_N lvc250s080caaaaaaaou
K15   o_SCPLD_SGPIO_DATA_OUT lvc250s080caaaaaaaou
| Models and submodels in the file (4): lvc250axxxggaaaaaain (Input), lvc250s080aaaaaaaaou (Output), lvc250s080caaaaaaaou (Output), lvc250s080gaaaaaaaio (I/O)
