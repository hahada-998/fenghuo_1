| IBIS Models Generator: Lattice Diamond (64-bit) 3.14.0.75.2
| Generate date: Mon Nov 03 16:28:36 2025
| IBIS File LibisMaker.ibs
| LibisGen v2.0.1.0, 02/25/2008, Lattice Semiconductor Corporation
| Modified by LibisMaker v2.0.1.0, 02/25/2008, Lattice Semiconductor
| North Carolina State University, ERL, 2006
[IBIS ver]   3.2
[File Name]   BM_H13DSP_S_impl1.ibs
[File Rev]   2.3
[Date]   Mon Aug  7 08:49:22 PDT 2023
[Source]   Lattice Semiconductor cs200fl Process
   LCMXO3LF-6900C   FINAL
   Lattice Semiconductor has worked hard to ensure the
   models below are accurate and complete.  However, the
   data below was generated using simulation of the
   input/output model files for the silicon.  Therefore,
   the data below is for reference and initial design
   purposes only.
   Lattice Semiconductor grants permission to use this
   data for use in printed circuit design using this
   Lattice programmable logic device.  Other use of this
   code, including the selling or duplication of any
   portion is strictly prohibited.
|   NAMING CONVENTION
   The IBIS [Model] header is limited by the specification to a
   total of characters.  With such a set of characters available
   for naming models it becomes important to attempt to
   meaningfully encode the IO standards so they fit within the
   twenty character limit.  It would seem that twenty characters
   would provide room enough for describing IO's.  However, the
   PLD IO structure continues to grow more and more complex.  The
   complexity is making the twenty characters insuffiently
   descriptive.  In order to overcome this issue the naming
   convention described below is implemented to resolve the issue.
The twenty character space is managed as follows:
   bbbvvvsdddprugtcoixx
   b = standard
   v = voltage (x.xx V)
   s = slew code
   d = drive (xx.x ma)
   p = pullup code
   r = series resistance  or bank_vccio code
   u = terminate to vcc code
   g = terminate to gnd code
   t = terminate to vtt code
   c = common mode termination mode
   o = diff resistor code
   i = diff resistor current code
   x = reserved
   standard
   LVCMOS   lvc
   lvcmosd   lvd
   lvcmosr   lvr
   LVDS25E   lve
   LVTTL   lvt
   lvttld   ltd
   PCI   pci
   pcix   pcx
   lvds25   lvs
   blvds25   blv
   blvds25e   blv
   mlvds25   mlv
   mlvds25e   mlv
   lvpecl33   lvp
   lvpecl33e   lvp
   cml   cml
   hypt   hyp
   rsds25   rsd
   rsds25e   rse
   mipi_lp   mip
   mipi   mip
   vref1   vr1
   vref2   vr2
   ref_res   rer
   slew
   na   a
   fast   f
   slow   s
   pullmode
   off   a
   pullup   b
   pulldown   c
   bushold   d
   clamp   e
   up_clamp   f
   down_clamp   g
   keeper_clamp   h
   impedance or Bank_vccio
   off   a
   25   b
   33   c
   50   d
   100   e
   3.3   f
   2.5   g
   1.8   h
   1.5   i
   1.2   j
   termVCC
   off   a
   50   b
   100   c
   120   d
   termGND
   off   a
   50   b
   100   c
   120   d
   termVTT
   off   a
   60   b
   75   c
   120   d
   150   e
   210   f
   VCMT
   off   a
   VCMT   b
   VTT   c
   DDR-2   d
   differential resistor
   off   a
   100   b
   diff drive
   NA   a
   2.0   b
   3.5   c
   1.25   f
   2.5   g
   Reserved   IO type
   in   input only
   ou   output
   io   I/O
   od   Open drain
   on   Inverting differential I/O
   (signal name only)
   op   Non-Inverting differential I/O
   (signal name only)
   Lattice Semiconductor Corporation
   5555 NE Moore Court
   Hillsboro, OR 97214
   U.S.A
   TEL: 1-800-Lattice (USA and Canada)
   408-826-6000 (other locations)
   web: http://www.latticesemi.com/
   email: techsupport@latticesemi.com
[Disclaimer] This IBIS source code is intended as a design reference
   which illustrates how the Lattice Semiconductor device operates.
   It is the user's responsibility to verify their design for
   consistency and functionality through the use of formal
   verification methods.  Lattice Semiconductor provides no warranty
   regarding the use or functionality of this data.
[Copyright]   Copyright 2007 by Lattice Semiconductor Corporation
|   Component XO3L
[Component]   XO3L
[Manufacturer]   Lattice Semiconductor Corp.
[Package]
|CABGA400
| variable   typ   min   max
R_pkg   355.0m   280.9m   425m
L_pkg   4.66nH   3.57nH   6.4nH
C_pkg   0.64pF   0.39pF   0.85pF
[Pin] signal_name   model_name   R_pin   L_pin   C_pin
N1   i_BOARD_ID0   lvc330axxxefaaaaaain
L1   i_BOARD_ID1   lvc330axxxefaaaaaain
K1   i_BOARD_ID2   lvc330axxxefaaaaaain
J1   i_BOARD_ID3   lvc330axxxefaaaaaain
J6   i_BREAK_DET1_DO_N   lvc330axxxefaaaaaain
F17   i_BREAK_DET_DO_N   lvc330axxxefaaaaaain
U1   i_CLK_PAL2_IN_25M   lvc330axxxefaaaaaain
A19   i_CPLD2_DONE   lvc330axxxefaaaaaain
K18   i_CPLD2_HOLD_N_R   lvc330axxxefaaaaaain
C17   i_CPLD2_INIT_N   lvc330axxxefaaaaaain
D13   i_CPLD2_PROGRAM_N   lvc330axxxefaaaaaain
Y20   i_CPLD2_SN   lvc330axxxefaaaaaain
L20   i_CPLD_SGPIO0_CLK   lvc330axxxefaaaaaain
M20   i_CPLD_SGPIO0_LD_N   lvc330axxxefaaaaaain
M19   i_CPLD_SGPIO0_MOSI   lvc330axxxefaaaaaain
N20   i_CPLD_SGPIO1_CLK   lvc330axxxefaaaaaain
L19   i_CPLD_SGPIO1_LD_N   lvc330axxxefaaaaaain
P20   i_CPLD_SGPIO1_MOSI   lvc330axxxefaaaaaain
B9   i_HDR_PAL2_N   lvc330axxxefaaaaaain
A18   i_I2C2_PAL2_SCL   lvc330axxxefaaaaaain
G10   i_JTAG_BMC_TRST_R   lvc330axxxefaaaaaain
K7   i_LEAKAGE_DET1_DO_N  lvc330axxxefaaaaaain
C16   i_LEAKAGE_DET_DO_N   lvc330axxxefaaaaaain
J5   i_LEAKAGE_PRSNT1_N   lvc330axxxefaaaaaain
D14   i_LEAKAGE_PRSNT_N   lvc330axxxefaaaaaain
F18   i_P0_MCIOG3A_CB_ID0_R lvc330axxxefaaaaaain
G17   i_P0_MCIOG3A_CB_ID1_R lvc330axxxefaaaaaain
C12   i_P0_MCIOG3A_NVME0_PRSNT_N_R lvc330axxxefaaaaaain
E17   i_P0_MCIOG3A_NVME1_PRSNT_N_R lvc330axxxefaaaaaain
G19   i_P0_MCIOG3A_WAKE_N_R lvc330axxxefaaaaaain
C19   i_P0_MCIOG3C_CB_ID0_R lvc330axxxefaaaaaain
C14   i_P0_MCIOG3C_CB_ID1_R lvc330axxxefaaaaaain
D6   i_P0_MCIOG3C_NVME0_PRSNT_N_R lvc330axxxefaaaaaain
E19   i_P0_MCIOG3C_NVME1_PRSNT_N_R lvc330axxxefaaaaaain
D19   i_P0_MCIOG3C_WAKE_N_R lvc330axxxefaaaaaain
W2   i_P0_MCIOP0A_CB_ID0_R lvc330axxxefaaaaaain
W4   i_P0_MCIOP0A_CB_ID1_R lvc330axxxefaaaaaain
Y3   i_P0_MCIOP0A_DATAIN  lvc330axxxefaaaaaain
Y4   i_P0_MCIOP0A_NVME0_PRSNT_N_R lvc330axxxefaaaaaain
W5   i_P0_MCIOP0A_NVME1_PRSNT_N_R lvc330axxxefaaaaaain
Y2   i_P0_MCIOP0A_WAKE_N_R lvc330axxxefaaaaaain
Y6   i_P0_MCIOP0C_CB_ID0_R lvc330axxxefaaaaaain
Y8   i_P0_MCIOP0C_CB_ID1_R lvc330axxxefaaaaaain
W9   i_P0_MCIOP0C_NVME0_PRSNT_N_R lvc330axxxefaaaaaain
V17   i_P0_MCIOP0C_NVME1_PRSNT_N_R lvc330axxxefaaaaaain
W7   i_P0_MCIOP0C_WAKE_N_R lvc330axxxefaaaaaain
Y10   i_P0_MCIOP1A_CB_ID0_R lvc330axxxefaaaaaain
W13   i_P0_MCIOP1A_CB_ID1_R lvc330axxxefaaaaaain
Y13   i_P0_MCIOP1A_NVME0_PRSNT_N_R lvc330axxxefaaaaaain
Y12   i_P0_MCIOP1A_NVME1_PRSNT_N_R lvc330axxxefaaaaaain
W11   i_P0_MCIOP1A_WAKE_N_R lvc330axxxefaaaaaain
W15   i_P0_MCIOP1C_CB_ID0_R lvc330axxxefaaaaaain
Y17   i_P0_MCIOP1C_CB_ID1_R lvc330axxxefaaaaaain
Y18   i_P0_MCIOP1C_NVME0_PRSNT_N_R lvc330axxxefaaaaaain
Y19   i_P0_MCIOP1C_NVME1_PRSNT_N_R lvc330axxxefaaaaaain
Y15   i_P0_MCIOP1C_WAKE_N_R lvc330axxxefaaaaaain
R16   i_P0_MCIOP2A_CB_ID0_R lvc330axxxefaaaaaain
P16   i_P0_MCIOP2A_CB_ID1_R lvc330axxxefaaaaaain
R13   i_P0_MCIOP2A_NVME0_PRSNT_N_R lvc330axxxefaaaaaain
P12   i_P0_MCIOP2A_NVME1_PRSNT_N_R lvc330axxxefaaaaaain
R8   i_P0_MCIOP2A_WAKE_N_R lvc330axxxefaaaaaain
D10   i_P0_MCIOP2C_CB_ID0_R lvc330axxxefaaaaaain
C10   i_P0_MCIOP2C_CB_ID1_R lvc330axxxefaaaaaain
E6   i_P0_MCIOP2C_NVME0_PRSNT_N_R lvc330axxxefaaaaaain
D7   i_P0_MCIOP2C_NVME1_PRSNT_N_R lvc330axxxefaaaaaain
D8   i_P0_MCIOP2C_WAKE_N_R lvc330axxxefaaaaaain
P10   i_P0_MCIOP3A_CB_ID0_R lvc330axxxefaaaaaain
P11   i_P0_MCIOP3A_CB_ID1_R lvc330axxxefaaaaaain
J18   i_P0_MCIOP3A_NVME0_PRSNT_N_R lvc330axxxefaaaaaain
K19   i_P0_MCIOP3A_NVME1_PRSNT_N_R lvc330axxxefaaaaaain
L17   i_P0_MCIOP3A_WAKE_N_R lvc330axxxefaaaaaain
R10   i_P0_MCIOP3C_CB_ID0_R lvc330axxxefaaaaaain
T9   i_P0_MCIOP3C_CB_ID1_R lvc330axxxefaaaaaain
N17   i_P0_MCIOP3C_NVME0_PRSNT_N_R lvc330axxxefaaaaaain
T17   i_P0_MCIOP3C_NVME1_PRSNT_N_R lvc330axxxefaaaaaain
N18   i_P0_MCIOP3C_WAKE_N_R lvc330axxxefaaaaaain
N15   i_P1_MCIOG1A_CB_ID0_R lvc330axxxefaaaaaain
P9   i_P1_MCIOG1A_CB_ID1_R lvc330axxxefaaaaaain
P15   i_P1_MCIOG1A_NVME0_PRSNT_N_R lvc330axxxefaaaaaain
T10   i_P1_MCIOG1A_NVME1_PRSNT_N_R lvc330axxxefaaaaaain
M7   i_P1_MCIOG1A_WAKE_N_R lvc330axxxefaaaaaain
R15   i_P1_MCIOG1C_CB_ID0_R lvc330axxxefaaaaaain
R14   i_P1_MCIOG1C_CB_ID1_R lvc330axxxefaaaaaain
R5   i_P1_MCIOG1C_NVME0_PRSNT_N_R lvc330axxxefaaaaaain
P5   i_P1_MCIOG1C_NVME1_PRSNT_N_R lvc330axxxefaaaaaain
R6   i_P1_MCIOG1C_WAKE_N_R lvc330axxxefaaaaaain
H6   i_P1_MCIOP0A_CB_ID0_R lvc330axxxefaaaaaain
C6   i_P1_MCIOP0A_CB_ID1_R lvc330axxxefaaaaaain
T6   i_P1_MCIOP0A_NVME0_PRSNT_N_R lvc330axxxefaaaaaain
R4   i_P1_MCIOP0A_NVME1_PRSNT_N_R lvc330axxxefaaaaaain
R3   i_P1_MCIOP0A_WAKE_N_R lvc330axxxefaaaaaain
P4   i_P1_MCIOP0C_CB_ID0_R lvc330axxxefaaaaaain
M6   i_P1_MCIOP0C_CB_ID1_R lvc330axxxefaaaaaain
K6   i_P1_MCIOP0C_NVME0_PRSNT_N_R lvc330axxxefaaaaaain
C4   i_P1_MCIOP0C_NVME1_PRSNT_N_R lvc330axxxefaaaaaain
E4   i_P1_MCIOP0C_WAKE_N_R lvc330axxxefaaaaaain
M4   i_P1_MCIOP1A_CB_ID0_R lvc330axxxefaaaaaain
N4   i_P1_MCIOP1A_CB_ID1_R lvc330axxxefaaaaaain
D2   i_P1_MCIOP1A_NVME0_PRSNT_N_R lvc330axxxefaaaaaain
C2   i_P1_MCIOP1A_NVME1_PRSNT_N_R lvc330axxxefaaaaaain
C3   i_P1_MCIOP1A_WAKE_N_R lvc330axxxefaaaaaain
L7   i_P1_MCIOP1C_CB_ID0_R lvc330axxxefaaaaaain
L6   i_P1_MCIOP1C_CB_ID1_R lvc330axxxefaaaaaain
M5   i_P1_MCIOP1C_NVME0_PRSNT_N_R lvc330axxxefaaaaaain
G4   i_P1_MCIOP1C_NVME1_PRSNT_N_R lvc330axxxefaaaaaain
F4   i_P1_MCIOP1C_WAKE_N_R lvc330axxxefaaaaaain
V3   i_P1_MCIOP2A_CB_ID0_R lvc330axxxefaaaaaain
J3   i_P1_MCIOP2A_CB_ID1_R lvc330axxxefaaaaaain
H2   i_P1_MCIOP2A_NVME0_PRSNT_N_R lvc330axxxefaaaaaain
R2   i_P1_MCIOP2A_NVME1_PRSNT_N_R lvc330axxxefaaaaaain
V2   i_P1_MCIOP2A_WAKE_N_R lvc330axxxefaaaaaain
U6   i_P1_MCIOP2C_CB_ID0_R lvc330axxxefaaaaaain
L2   i_P1_MCIOP2C_CB_ID1_R lvc330axxxefaaaaaain
K4   i_P1_MCIOP2C_NVME0_PRSNT_N_R lvc330axxxefaaaaaain
U4   i_P1_MCIOP2C_NVME1_PRSNT_N_R lvc330axxxefaaaaaain
U5   i_P1_MCIOP2C_WAKE_N_R lvc330axxxefaaaaaain
N2   i_P1_MCIOP3A_CB_ID0_R lvc330axxxefaaaaaain
T8   i_P1_MCIOP3A_CB_ID1_R lvc330axxxefaaaaaain
F8   i_P1_MCIOP3A_NVME0_PRSNT_N_R lvc330axxxefaaaaaain
L3   i_P1_MCIOP3A_NVME1_PRSNT_N_R lvc330axxxefaaaaaain
M3   i_P1_MCIOP3A_WAKE_N_R lvc330axxxefaaaaaain
R1   i_P1_MCIOP3C_CB_ID0_R lvc330axxxefaaaaaain
V10   i_P1_MCIOP3C_CB_ID1_R lvc330axxxefaaaaaain
E7   i_P1_MCIOP3C_NVME0_PRSNT_N_R lvc330axxxefaaaaaain
N3   i_P1_MCIOP3C_NVME1_PRSNT_N_R lvc330axxxefaaaaaain
P2   i_P1_MCIOP3C_WAKE_N_R lvc330axxxefaaaaaain
L5   i_P1_MCIOP4A_NVME0_PRSNT_N_R lvc330axxxefaaaaaain
F16   i_PAL_NODE1_TYPE   lvc330axxxefaaaaaain
U12   i_PAL_P12V_CPU0_DIMM_GOK lvc330axxxefaaaaaain
V13   i_PAL_P12V_CPU0_DIMM_OC lvc330axxxefaaaaaain
J19   i_PAL_P12V_CPU1_DIMM_GOK lvc330axxxefaaaaaain
K16   i_PAL_P12V_CPU1_DIMM_OC lvc330axxxefaaaaaain
F12   i_PAL_PCH_INTRUDER   lvc330axxxefaaaaaain
B20   i_PAL_PE_WAKE_N   lvc330axxxefaaaaaain
E14   i_PAL_SLIMSAS1_PRSNT_N lvc330axxxefaaaaaain
G11   i_PAL_TMP1_ALERT_N   lvc330axxxefaaaaaain
F5   i_PAL_TMP2_ALERT_N   lvc330axxxefaaaaaain
F10   i_PAL_TMP3_ALERT_N   lvc330axxxefaaaaaain
F7   i_PAL_TMP4_ALERT_N   lvc330axxxefaaaaaain
E1   i_PCA_REVISION_0   lvc330axxxefaaaaaain
D1   i_PCA_REVISION_1   lvc330axxxefaaaaaain
C1   i_PCA_REVISION_2   lvc330axxxefaaaaaain
H1   i_PCB_REVISION_0   lvc330axxxefaaaaaain
G1   i_PCB_REVISION_1   lvc330axxxefaaaaaain
F1   i_PCB_REVISION_2   lvc330axxxefaaaaaain
D16   i_PCH_INTRUDER_CABLE_INST_R_N lvc330axxxefaaaaaain
G9   i_PWRGD_SYS_PWROK_R  lvc330axxxefaaaaaain
B12   i_SMB_CPU0_ALERT_N_R lvc330axxxefaaaaaain
A2   i_SW_1   lvc330axxxefaaaaaain
A3   i_SW_3   lvc330axxxefaaaaaain
B4   i_SW_4   lvc330axxxefaaaaaain
A4   i_SW_5   lvc330axxxefaaaaaain
B5   i_SW_6   lvc330axxxefaaaaaain
A5   i_SW_7   lvc330axxxefaaaaaain
B6   i_SW_8   lvc330axxxefaaaaaain
C11   io_I2C2_2_UPDATE_SCL lvc330s080eaaaaaaaio
D11   io_I2C2_2_UPDATE_SDA lvc330s080eaaaaaaaio
B18   io_I2C2_PAL2_SDA   lvc330s080eaaaaaaaio
F19   io_P0_MCIOG3A_PWR_EN_R lvc330s080eaaaaaaaio
B19   io_P0_MCIOG3C_PWR_EN_R lvc330s080eaaaaaaaio
W1   io_P0_MCIOP0A_PWR_EN_R lvc330s080eaaaaaaaio
Y5   io_P0_MCIOP0C_PWR_EN_R lvc330s080eaaaaaaaio
Y9   io_P0_MCIOP1A_PWR_EN_R lvc330s080eaaaaaaaio
W14   io_P0_MCIOP1C_PWR_EN_R lvc330s080eaaaaaaaio
L14   io_P0_MCIOP2A_PWR_EN_R lvc330s080eaaaaaaaio
B8   io_P0_MCIOP2C_PWR_EN_R lvc330s080eaaaaaaaio
P17   io_P0_MCIOP3A_PWR_EN_R lvc330s080eaaaaaaaio
T16   io_P0_MCIOP3C_PWR_EN_R lvc330s080eaaaaaaaio
T13   io_P1_MCIOG1A_PWR_EN_R lvc330s080eaaaaaaaio
R9   io_P1_MCIOG1C_PWR_EN_R lvc330s080eaaaaaaaio
T5   io_P1_MCIOP0A_PWR_EN_R lvc330s080eaaaaaaaio
D5   io_P1_MCIOP0C_PWR_EN_R lvc330s080eaaaaaaaio
J4   io_P1_MCIOP1A_PWR_EN_R lvc330s080eaaaaaaaio
E2   io_P1_MCIOP1C_PWR_EN_R lvc330s080eaaaaaaaio
H3   io_P1_MCIOP2A_PWR_EN_R lvc330s080eaaaaaaaio
K5   io_P1_MCIOP2C_PWR_EN_R lvc330s080eaaaaaaaio
V8   io_P1_MCIOP3A_PWR_EN_R lvc330s080eaaaaaaaio
U10   io_P1_MCIOP3C_PWR_EN_R lvc330s080eaaaaaaaio
A11   o_BIOS_FLASH_RESET_R_N lvc330s080aaaaaaaaou
P1   o_CLK_DB2000_2_1_OE_N lvc330s080aaaaaaaaou
A1   o_CLK_DB2000_2_2_OE_N lvc330s080aaaaaaaaou
A16   o_CLK_GEN_FDEC_R   lvc330s080aaaaaaaaou
T20   o_CLK_GEN_FINC_R   lvc330s080aaaaaaaaou
A17   o_CLK_GEN_I2C_SEL_R  lvc330s080aaaaaaaaou
A13   o_CLK_GEN_INTR_N_R   lvc330s080aaaaaaaaou
U20   o_CLK_GEN_LOL_N_R   lvc330s080aaaaaaaaou
A15   o_CLK_GEN_OE_N_R   lvc330s080aaaaaaaaou
A14   o_CLK_GEN_RST_N_R   lvc330s080aaaaaaaaou
W20   o_CPLD1_CPLD2_RSV1_R lvc330s080aaaaaaaaou
C13   o_CPLD2_JTAGEN   lvc330s080aaaaaaaaou
R20   o_CPLD_SGPIO0_MISO   lvc330s080aaaaaaaaou
T19   o_CPLD_SGPIO1_MISO   lvc330s080aaaaaaaaou
K20   o_LED1_N   lvc330s080aaaaaaaaou
C20   o_LED2_N   lvc330s080aaaaaaaaou
D20   o_LED3_N   lvc330s080aaaaaaaaou
E20   o_LED4_N   lvc330s080aaaaaaaaou
J20   o_LED5_N   lvc330s080aaaaaaaaou
H20   o_LED6_N   lvc330s080aaaaaaaaou
G20   o_LED7_N   lvc330s080aaaaaaaaou
F20   o_LED8_N   lvc330s080aaaaaaaaou
M15   o_M2_GPIO6_R   lvc330s080aaaaaaaaou
M16   o_M2_GPIO7_R   lvc330s080aaaaaaaaou
A6   o_P0_I2C5_9617_EN   lvc330s080aaaaaaaaou
D18   o_P0_MCIOG3A_GPU_THROTTLE_N_R lvc330s080aaaaaaaaou
D12   o_P0_MCIOG3A_PERST_N_R lvc330s080aaaaaaaaou
H18   o_P0_MCIOG3A_RSV_R   lvc330s080aaaaaaaaou
D17   o_P0_MCIOG3C_GPU_THROTTLE_N_R lvc330s080aaaaaaaaou
F11   o_P0_MCIOG3C_PERST_N_R lvc330s080aaaaaaaaou
C18   o_P0_MCIOG3C_RSV_R   lvc330s080aaaaaaaaou
U17   o_P0_MCIOP0A_CLK   lvc330s080aaaaaaaaou
Y1   o_P0_MCIOP0A_GPU_THROTTLE_N_R lvc330s080aaaaaaaaou
U18   o_P0_MCIOP0A_LD   lvc330s080aaaaaaaaou
T7   o_P0_MCIOP0A_PERST_N_R lvc330s080aaaaaaaaou
W3   o_P0_MCIOP0A_RSV_R   lvc330s080aaaaaaaaou
W6   o_P0_MCIOP0C_GPU_THROTTLE_N_R lvc330s080aaaaaaaaou
W8   o_P0_MCIOP0C_PERST_N_R lvc330s080aaaaaaaaou
Y7   o_P0_MCIOP0C_RSV_R   lvc330s080aaaaaaaaou
W10   o_P0_MCIOP1A_GPU_THROTTLE_N_R lvc330s080aaaaaaaaou
W12   o_P0_MCIOP1A_PERST_N_R lvc330s080aaaaaaaaou
Y11   o_P0_MCIOP1A_RSV_R   lvc330s080aaaaaaaaou
Y14   o_P0_MCIOP1C_GPU_THROTTLE_N_R lvc330s080aaaaaaaaou
Y16   o_P0_MCIOP1C_PERST_N_R lvc330s080aaaaaaaaou
W16   o_P0_MCIOP1C_RSV_R   lvc330s080aaaaaaaaou
N16   o_P0_MCIOP2A_GPU_THROTTLE_N_R lvc330s080aaaaaaaaou
K17   o_P0_MCIOP2A_PERST_N_R lvc330s080aaaaaaaaou
R11   o_P0_MCIOP2A_RSV_R   lvc330s080aaaaaaaaou
A8   o_P0_MCIOP2C_GPU_THROTTLE_N_R lvc330s080aaaaaaaaou
F6   o_P0_MCIOP2C_PERST_N_R lvc330s080aaaaaaaaou
F9   o_P0_MCIOP2C_RSV_R   lvc330s080aaaaaaaaou
T18   o_P0_MCIOP3A_GPU_THROTTLE_N_R lvc330s080aaaaaaaaou
R17   o_P0_MCIOP3A_PERST_N_R lvc330s080aaaaaaaaou
M18   o_P0_MCIOP3A_RSV_R   lvc330s080aaaaaaaaou
U15   o_P0_MCIOP3C_GPU_THROTTLE_N_R lvc330s080aaaaaaaaou
U14   o_P0_MCIOP3C_PERST_N_R lvc330s080aaaaaaaaou
P18   o_P0_MCIOP3C_RSV_R   lvc330s080aaaaaaaaou
H7   o_P0_MCIOP4A_PERST_N_R lvc330s080aaaaaaaaou
C15   o_P0_SPI_TPM_CS_N_3V3 lvc330s080aaaaaaaaou
L16   o_P12V_DISCHARGE_R   lvc330s080aaaaaaaaou
T12   o_P1_MCIOG1A_GPU_THROTTLE_N_R lvc330s080aaaaaaaaou
P8   o_P1_MCIOG1A_PERST_N_R lvc330s080aaaaaaaaou
R12   o_P1_MCIOG1A_RSV_R   lvc330s080aaaaaaaaou
P6   o_P1_MCIOG1C_GPU_THROTTLE_N_R lvc330s080aaaaaaaaou
N5   o_P1_MCIOG1C_PERST_N_R lvc330s080aaaaaaaaou
N6   o_P1_MCIOG1C_RSV_R   lvc330s080aaaaaaaaou
T4   o_P1_MCIOP0A_GPU_THROTTLE_N_R lvc330s080aaaaaaaaou
R7   o_P1_MCIOP0A_PERST_N_R lvc330s080aaaaaaaaou
T3   o_P1_MCIOP0A_RSV_R   lvc330s080aaaaaaaaou
N14   o_P1_MCIOP0C_GPU_THROTTLE_N_R lvc330s080aaaaaaaaou
P13   o_P1_MCIOP0C_PERST_N_R lvc330s080aaaaaaaaou
P14   o_P1_MCIOP0C_RSV_R   lvc330s080aaaaaaaaou
E3   o_P1_MCIOP1A_GPU_THROTTLE_N_R lvc330s080aaaaaaaaou
B2   o_P1_MCIOP1A_PERST_N_R lvc330s080aaaaaaaaou
F3   o_P1_MCIOP1A_RSV_R   lvc330s080aaaaaaaaou
F2   o_P1_MCIOP1C_GPU_THROTTLE_N_R lvc330s080aaaaaaaaou
H4   o_P1_MCIOP1C_PERST_N_R lvc330s080aaaaaaaaou
G2   o_P1_MCIOP1C_RSV_R   lvc330s080aaaaaaaaou
G3   o_P1_MCIOP2A_GPU_THROTTLE_N_R lvc330s080aaaaaaaaou
J2   o_P1_MCIOP2A_PERST_N_R lvc330s080aaaaaaaaou
V4   o_P1_MCIOP2A_RSV_R   lvc330s080aaaaaaaaou
K2   o_P1_MCIOP2C_GPU_THROTTLE_N_R lvc330s080aaaaaaaaou
L4   o_P1_MCIOP2C_PERST_N_R lvc330s080aaaaaaaaou
V6   o_P1_MCIOP2C_RSV_R   lvc330s080aaaaaaaaou
U9   o_P1_MCIOP3A_GPU_THROTTLE_N_R lvc330s080aaaaaaaaou
V9   o_P1_MCIOP3A_PERST_N_R lvc330s080aaaaaaaaou
M2   o_P1_MCIOP3A_RSV_R   lvc330s080aaaaaaaaou
U11   o_P1_MCIOP3C_GPU_THROTTLE_N_R lvc330s080aaaaaaaaou
T11   o_P1_MCIOP3C_PERST_N_R lvc330s080aaaaaaaaou
P3   o_P1_MCIOP3C_RSV_R   lvc330s080aaaaaaaaou
G5   o_P1_MCIOP4A_PERST_N_R lvc330s080aaaaaaaaou
V12   o_PAL_P12V_CPU0_DIMM_ON lvc330s080aaaaaaaaou
M17   o_PAL_P12V_CPU1_DIMM_ON lvc330s080aaaaaaaaou
H19   o_PAL_SPI1_BMC_HOLD  lvc330s080aaaaaaaaou
J16   o_PAL_SPI_BIOS_UPDATA_EN lvc330s080aaaaaaaaou
V19   o_PCIE_SATA_RST_N   lvc330s080aaaaaaaaou
L15   o_PCIE_SATA_WAKE_R_N lvc330s080aaaaaaaaou
B1   o_RST_I2C1_MUX_N_R   lvc330s080aaaaaaaaou
B17   o_RST_I2C2_MUX_N_R   lvc330s080aaaaaaaaou
A20   o_RST_I2C3_MUX_N_R   lvc330s080aaaaaaaaou
F14   o_SATA1_RSV   lvc330s080aaaaaaaaou
V16   o_SMB_PEHP_CPU0_OCP_ALERT lvc330s080aaaaaaaaou
M1   o_SMB_PEHP_CPU1_OCP_ALERT lvc330s080aaaaaaaaou
A10   o_SW_BIOS_FLASH_SPI_S_R lvc330s080aaaaaaaaou
A12   o_SW_BIOS_QSPI_S_R   lvc330s080aaaaaaaaou
A9   o_SW_BIOS_SPI_OE   lvc330s080aaaaaaaaou
B16   o_SW_QSPI_OE_R   lvc330s080aaaaaaaaou
| Models and submodels in the file (3): lvc330axxxefaaaaaain (Input), lvc330s080aaaaaaaaou (Output), lvc330s080eaaaaaaaio (I/O)
