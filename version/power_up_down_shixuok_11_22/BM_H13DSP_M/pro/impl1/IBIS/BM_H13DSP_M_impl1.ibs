| IBIS Models Generator: Lattice Diamond (64-bit) 3.14.0.75.2
| Generate date: Tue Nov 18 16:02:48 2025
| IBIS File LibisMaker.ibs
| LibisGen v2.0.1.0, 02/25/2008, Lattice Semiconductor Corporation
| Modified by LibisMaker v2.0.1.0, 02/25/2008, Lattice Semiconductor
| North Carolina State University, ERL, 2006
[IBIS ver]   3.2
[File Name]   BM_H13DSP_M_impl1.ibs
[File Rev]   2.3
[Date]   Mon Aug  7 08:49:22 PDT 2023
[Source]   Lattice Semiconductor cs200fl Process
   LCMXO3LF-6900C   FINAL
   Lattice Semiconductor has worked hard to ensure the
   models below are accurate and complete.  However, the
   data below was generated using simulation of the
   input/output model files for the silicon.  Therefore,
   the data below is for reference and initial design
   purposes only.
   Lattice Semiconductor grants permission to use this
   data for use in printed circuit design using this
   Lattice programmable logic device.  Other use of this
   code, including the selling or duplication of any
   portion is strictly prohibited.
|   NAMING CONVENTION
   The IBIS [Model] header is limited by the specification to a
   total of characters.  With such a set of characters available
   for naming models it becomes important to attempt to
   meaningfully encode the IO standards so they fit within the
   twenty character limit.  It would seem that twenty characters
   would provide room enough for describing IO's.  However, the
   PLD IO structure continues to grow more and more complex.  The
   complexity is making the twenty characters insuffiently
   descriptive.  In order to overcome this issue the naming
   convention described below is implemented to resolve the issue.
The twenty character space is managed as follows:
   bbbvvvsdddprugtcoixx
   b = standard
   v = voltage (x.xx V)
   s = slew code
   d = drive (xx.x ma)
   p = pullup code
   r = series resistance  or bank_vccio code
   u = terminate to vcc code
   g = terminate to gnd code
   t = terminate to vtt code
   c = common mode termination mode
   o = diff resistor code
   i = diff resistor current code
   x = reserved
   standard
   LVCMOS   lvc
   lvcmosd   lvd
   lvcmosr   lvr
   LVDS25E   lve
   LVTTL   lvt
   lvttld   ltd
   PCI   pci
   pcix   pcx
   lvds25   lvs
   blvds25   blv
   blvds25e   blv
   mlvds25   mlv
   mlvds25e   mlv
   lvpecl33   lvp
   lvpecl33e   lvp
   cml   cml
   hypt   hyp
   rsds25   rsd
   rsds25e   rse
   mipi_lp   mip
   mipi   mip
   vref1   vr1
   vref2   vr2
   ref_res   rer
   slew
   na   a
   fast   f
   slow   s
   pullmode
   off   a
   pullup   b
   pulldown   c
   bushold   d
   clamp   e
   up_clamp   f
   down_clamp   g
   keeper_clamp   h
   impedance or Bank_vccio
   off   a
   25   b
   33   c
   50   d
   100   e
   3.3   f
   2.5   g
   1.8   h
   1.5   i
   1.2   j
   termVCC
   off   a
   50   b
   100   c
   120   d
   termGND
   off   a
   50   b
   100   c
   120   d
   termVTT
   off   a
   60   b
   75   c
   120   d
   150   e
   210   f
   VCMT
   off   a
   VCMT   b
   VTT   c
   DDR-2   d
   differential resistor
   off   a
   100   b
   diff drive
   NA   a
   2.0   b
   3.5   c
   1.25   f
   2.5   g
   Reserved   IO type
   in   input only
   ou   output
   io   I/O
   od   Open drain
   on   Inverting differential I/O
   (signal name only)
   op   Non-Inverting differential I/O
   (signal name only)
   Lattice Semiconductor Corporation
   5555 NE Moore Court
   Hillsboro, OR 97214
   U.S.A
   TEL: 1-800-Lattice (USA and Canada)
   408-826-6000 (other locations)
   web: http://www.latticesemi.com/
   email: techsupport@latticesemi.com
[Disclaimer] This IBIS source code is intended as a design reference
   which illustrates how the Lattice Semiconductor device operates.
   It is the user's responsibility to verify their design for
   consistency and functionality through the use of formal
   verification methods.  Lattice Semiconductor provides no warranty
   regarding the use or functionality of this data.
[Copyright]   Copyright 2007 by Lattice Semiconductor Corporation
|   Component XO3L
[Component]   XO3L
[Manufacturer]   Lattice Semiconductor Corp.
[Package]
|CABGA400
| variable   typ   min   max
R_pkg   355.0m   280.9m   425m
L_pkg   4.66nH   3.57nH   6.4nH
C_pkg   0.64pF   0.39pF   0.85pF
[Pin] signal_name   model_name   R_pin   L_pin   C_pin
E2   i_CLK_25M_CPLD   lvc330axxxgfaaaaaain
W15   i_CPLD1_CPLD2_RSV1   lvc330axxxefaaaaaain
P15   i_CPLD_ESPI_CLK   lvc180axxxehaaaaaain
N19   i_CPLD_ESPI_CS_N   lvc180axxxehaaaaaain
N14   i_CPLD_ESPI_D0   lvc180axxxehaaaaaain
U17   i_CPLD_ESPI_RESET_N  lvc180axxxehaaaaaain
Y14   i_CPLD_SGPIO0_MISO_R lvc330axxxefaaaaaain
B7   i_FM_CPU_SMERR_LVC3_N_R lvc330axxxefaaaaaain
A13   i_FM_PWRBTN_OUT_N_R  lvc330axxxefaaaaaain
K1   i_FM_RSTBTN_OUT_N_R  lvc330axxxefaaaaaain
W9   i_I2C2_PAL_SCL   lvc330axxxefaaaaaain
D18   i_P0_BIOS_POST_STAGE_R_N lvc180axxxehaaaaaain
T16   i_P0_CORETYPE_0   lvc330axxxefaaaaaain
W20   i_P0_CORETYPE_1   lvc330axxxefaaaaaain
U15   i_P0_CORETYPE_2   lvc330axxxefaaaaaain
Y2   i_P0_CPLD_SCL   lvc330axxxefaaaaaain
N15   i_P0_I3C_APML_ALERT_N lvc180axxxehaaaaaain
H20   i_P0_PCIE_RST_N_0   lvc180axxxehaaaaaain
F20   i_P0_PCIE_RST_N_1   lvc180axxxehaaaaaain
B16   i_P0_PRSNT_N   lvc330axxxefaaaaaain
J15   i_P0_PWRGD_OUT   lvc180axxxehaaaaaain
M20   i_P0_PWROK   lvc180axxxehaaaaaain
K17   i_P0_RESET_N   lvc180axxxehaaaaaain
F16   i_P0_SLP_S3_N   lvc180axxxehaaaaaain
G16   i_P0_SLP_S5_N   lvc180axxxehaaaaaain
E17   i_P0_SMERR_N   lvc180axxxehaaaaaain
A7   i_P0_SP5R_R_1   lvc330axxxefaaaaaain
B15   i_P0_SP5R_R_2   lvc330axxxefaaaaaain
R15   i_P0_SP5R_R_3   lvc330axxxefaaaaaain
K6   i_P0_SP5R_R_4   lvc330axxxefaaaaaain
M15   i_P0_SPD_HOST_CTRL_N lvc180axxxehaaaaaain
G17   i_P0_THERMTRIP_N   lvc180axxxehaaaaaain
K15   i_P0_UART_TXD_1   lvc180axxxehaaaaaain
P7   i_P0_USB_OC2_N_R   lvc330axxxefaaaaaain
B18   i_P0_VDDIO_OCP_N   lvc330axxxefaaaaaain
E20   i_P0_VDD_CORE_0_OCP_N_R lvc180axxxehaaaaaain
F11   i_P0_VR_I2C_ALERT_N  lvc330axxxefaaaaaain
V10   i_P1_CORETYPE_0   lvc330axxxefaaaaaain
T7   i_P1_CORETYPE_1   lvc330axxxefaaaaaain
T10   i_P1_CORETYPE_2   lvc330axxxefaaaaaain
K19   i_P1_I3C_APML_ALERT_N lvc180axxxehaaaaaain
P16   i_P1_PCIE_RST_N_0   lvc180axxxehaaaaaain
T17   i_P1_PCIE_RST_N_1   lvc180axxxehaaaaaain
R10   i_P1_PRSNT_N   lvc330axxxefaaaaaain
P17   i_P1_PWRGD_OUT   lvc180axxxehaaaaaain
K18   i_P1_PWROK   lvc180axxxehaaaaaain
C20   i_P1_RESET_N   lvc180axxxehaaaaaain
M17   i_P1_SMERR_N   lvc180axxxehaaaaaain
P8   i_P1_SP5R_R_1   lvc330axxxefaaaaaain
V9   i_P1_SP5R_R_2   lvc330axxxefaaaaaain
U9   i_P1_SP5R_R_3   lvc330axxxefaaaaaain
P12   i_P1_SP5R_R_4   lvc330axxxefaaaaaain
M18   i_P1_THERMTRIP_N   lvc180axxxehaaaaaain
W16   i_P1_VDDIO_OCP_N   lvc330axxxefaaaaaain
N18   i_P1_VDD_CORE_0_OCP_N_R lvc180axxxehaaaaaain
U14   i_P1_VR_I2C_ALERT_N  lvc330axxxefaaaaaain
U19   i_PAL_P0_VDD_CORE_1_OCP_N lvc180axxxehaaaaaain
T19   i_PAL_P1_VDD_CORE_1_OCP_N lvc180axxxehaaaaaain
B3   i_PWRGD_P3V3_STBY   lvc330axxxefaaaaaain
W2   i_RTC_INTA_N   lvc330axxxefaaaaaain
A14   i_SS_PAL_DATA_IN_R   lvc330axxxefaaaaaain
Y9   io_I2C2_PAL_SDA   lvc330s080eaaaaaaaio
C11   io_I2C2_UPDATE_SCL   lvc330s080eaaaaaaaio
D11   io_I2C2_UPDATE_SDA   lvc330s080eaaaaaaaio
Y3   io_P0_CPLD_SDA   lvc330s080afaaaaaaod
B14   o_BIOS_POST_CMPLT_BMC_N_R lvc330s080aaaaaaaaou
T9   o_BMC_I2C4_9548_1_RST_N_R lvc330s080aaaaaaaaou
F8   o_BMC_I2C4_9548_2_RST_N_R lvc330s080aaaaaaaaou
D14   o_BMC_I2C4_9548_3_RST_N_R lvc330s080aaaaaaaaou
T8   o_BMC_I2C4_9548_4_RST_N_R lvc330s080aaaaaaaaou
A1   o_BMC_JTAG_MUX_S   lvc330s080aaaaaaaaou
C16   o_BMC_JTAG_TRST_R_N  lvc330s080aaaaaaaaou
B6   o_CLK_DB2000_1_1_OE_N lvc330s080aaaaaaaaou
B5   o_CLK_DB2000_1_2_OE_N lvc330s080aaaaaaaaou
Y15   o_CPLD1_CPLD2_RSV2   lvc330s080aaaaaaaaou
R17   o_CPLD_ESPI_ALERT_N  lvc180s080aaaaaaaaou
R16   o_CPLD_ESPI_D1   lvc180s080aaaaaaaaou
M14   o_CPLD_ESPI_D2   lvc180s080aaaaaaaaou
V17   o_CPLD_ESPI_D3   lvc180s080aaaaaaaaou
W11   o_CPLD_SGPIO0_CLK_R  lvc330s080aaaaaaaaou
W12   o_CPLD_SGPIO0_LD_N_R lvc330s080aaaaaaaaou
Y12   o_CPLD_SGPIO0_MOSI_R lvc330s080aaaaaaaaou
Y13   o_CPLD_SGPIO1_CLK_R  lvc330s080aaaaaaaaou
Y11   o_CPLD_SGPIO1_LD_N_R lvc330s080aaaaaaaaou
W13   o_CPLD_SGPIO1_MOSI_R lvc330s080aaaaaaaaou
G2   o_EEPROM_WP_N_R   lvc330s080aaaaaaaaou
N20   o_HDT_CPU_PWROK   lvc180s080aaaaaaaaou
P20   o_HDT_CPU_RESET_N   lvc180s080aaaaaaaaou
L1   o_I3C_MUX_OE_N_R_0   lvc330s080aaaaaaaaou
M2   o_I3C_MUX_OE_N_R_1   lvc330s080aaaaaaaaou
P9   o_I3C_MUX_OE_N_R_2   lvc330s080aaaaaaaaou
R7   o_I3C_MUX_OE_N_R_3   lvc330s080aaaaaaaaou
M1   o_I3C_MUX_SEL_R_0   lvc330s080aaaaaaaaou
L2   o_I3C_MUX_SEL_R_1   lvc330s080aaaaaaaaou
P10   o_I3C_MUX_SEL_R_2   lvc330s080aaaaaaaaou
R9   o_I3C_MUX_SEL_R_3   lvc330s080aaaaaaaaou
T14   o_P0_DIMM_AF_PCAMP_R lvc330s080aaaaaaaaou
A8   o_P0_DIMM_GL_PCAMP_R lvc330s080aaaaaaaaou
T20   o_P0_FORCE_SELFREFRESH_R lvc180s080aaaaaaaaou
B2   o_P0_I2C_9617_EN   lvc330s080aaaaaaaaou
U20   o_P0_KBRST_N   lvc180s080aaaaaaaaou
H19   o_P0_NMI_SYNC_FLOOD_N lvc180s080aaaaaaaaou
L19   o_P0_PCIE_WAKE_N_R   lvc180s080aaaaaaaaou
L20   o_P0_PROCHOT_N   lvc180s080aaaaaaaaou
C18   o_P0_PWR_BTN_R_N   lvc180s080aaaaaaaaou
L16   o_P0_PWR_GOOD   lvc180s080aaaaaaaaou
D17   o_P0_RSMRST_N   lvc180s080aaaaaaaaou
B20   o_P0_SPI_CLK_STRAP   lvc180s080aaaaaaaaou
F18   o_P0_SYS_RESET_R_N   lvc180s080aaaaaaaaou
F19   o_P0_UART_RXD_0   lvc180s080aaaaaaaaou
M19   o_P0_UART_RXD_1   lvc180s080aaaaaaaaou
U1   o_P0_VDD_3V3_STBY_EN_R lvc330s080aaaaaaaaou
E1   o_P0_VPP_9545_1_RST_N_R lvc330s080aaaaaaaaou
W19   o_P0_VPP_9545_2_RST_N_R lvc330s080aaaaaaaaou
M6   o_P0_VPP_9545_3_RST_N_R lvc330s080aaaaaaaaou
L6   o_P0_VPP_9545_4_RST_N_R lvc330s080aaaaaaaaou
C15   o_P0_VPP_9545_5_RST_N_R lvc330s080aaaaaaaaou
M3   o_P0_VPP_9545_6_RST_N_R lvc330s080aaaaaaaaou
P19   o_P0_WAFL_STRAP_SEL_R lvc180s080aaaaaaaaou
D1   o_P1V0_STBY_M2_EN   lvc330s080aaaaaaaaou
P13   o_P1_DIMM_AF_PCAMP_R lvc330s080aaaaaaaaou
V16   o_P1_DIMM_GL_PCAMP_R lvc330s080aaaaaaaaou
U18   o_P1_FORCE_SELFREFRESH_R lvc180s080aaaaaaaaou
V20   o_P1_KBRST_N   lvc180s080aaaaaaaaou
P18   o_P1_NMI_SYNC_FLOOD_N lvc180s080aaaaaaaaou
R19   o_P1_PCIE_WAKE_N_R   lvc180s080aaaaaaaaou
T18   o_P1_PROCHOT_N   lvc180s080aaaaaaaaou
Y19   o_P1_PWR_BTN_N   lvc330s080aaaaaaaaou
L15   o_P1_PWR_GOOD   lvc180s080aaaaaaaaou
N17   o_P1_RSMRST_N   lvc180s080aaaaaaaaou
V19   o_P1_SYS_RESET_N   lvc330s120ahaaaaaaod
T13   o_P1_VDDIO_RST_L_N   lvc330s080aaaaaaaaou
P11   o_P1_VDD_3V3_STBY_EN_R lvc330s080aaaaaaaaou
V8   o_PAL_BAT_SENSE_R   lvc330s080aaaaaaaaou
D20   o_PAL_BIOS_DEBUG_R_N lvc180s080aaaaaaaaou
W17   o_PAL_BMC_AUX_PGD   lvc330s080aaaaaaaaou
C1   o_PAL_BMC_PERST_N_R  lvc330s080aaaaaaaaou
G19   o_PAL_BMC_POST_DONE_FLAG_R lvc180s080aaaaaaaaou
J19   o_PAL_CLEAR_CMOS_R_N lvc180s080aaaaaaaaou
A2   o_PAL_CMOS_CLEAR_R   lvc330s080aaaaaaaaou
A5   o_PAL_DB2000_1_PWRGD_R lvc330s080aaaaaaaaou
V12   o_PAL_DB2000_2_PWRGD_R lvc330s080aaaaaaaaou
G12   o_PAL_I3C_MUX_EN_R_N lvc330s080aaaaaaaaou
Y17   o_PAL_P0_I2C5_9548_RST_R lvc330s080aaaaaaaaou
E19   o_PAL_P0_PRSENT_HDT  lvc180s080aaaaaaaaou
F12   o_PAL_P0_VDDIO_EN_R  lvc330s080aaaaaaaaou
C14   o_PAL_P0_VDDIO_RST_N lvc330s080aaaaaaaaou
A17   o_PAL_P0_VDD_11_SUS_EN lvc330s080aaaaaaaaou
R1   o_PAL_P0_VDD_18_STBY_EN_R lvc330s080aaaaaaaaou
U2   o_PAL_P0_VDD_CORE_0_EN_R lvc330s080aaaaaaaaou
T2   o_PAL_P0_VDD_CORE_0_SOC_RST_L_N lvc330s080aaaaaaaaou
A20   o_PAL_P0_VDD_CORE_1_11_SUS_RST_L_N lvc330s160afaaaaaaod
B19   o_PAL_P0_VDD_CORE_1_EN_R lvc330s080aaaaaaaaou
W1   o_PAL_P0_VDD_SOC_EN  lvc330s080aaaaaaaaou
T6   o_PAL_P12V_CPU0_ON   lvc330s080aaaaaaaaou
N6   o_PAL_P12V_CPU1_ON   lvc330s080aaaaaaaaou
K14   o_PAL_P1_PRSENT_HDT  lvc180s080aaaaaaaaou
V13   o_PAL_P1_VDDIO_EN_R  lvc330s080aaaaaaaaou
R13   o_PAL_P1_VDD_11_SUS_EN lvc330s080aaaaaaaaou
W8   o_PAL_P1_VDD_18_STBY_EN_R lvc330s080aaaaaaaaou
P14   o_PAL_P1_VDD_CORE_0_EN_R lvc330s080aaaaaaaaou
R14   o_PAL_P1_VDD_CORE_0_SOC_RST_L_N lvc330s080aaaaaaaaou
R11   o_PAL_P1_VDD_CORE_1_11_SUS_RST_L_N lvc330s160afaaaaaaod
U11   o_PAL_P1_VDD_CORE_1_EN_R lvc330s080aaaaaaaaou
R8   o_PAL_P1_VDD_SOC_EN  lvc330s080aaaaaaaaou
F9   o_PAL_PVCC_HPMOS_EN_R lvc330s080aaaaaaaaou
V1   o_PAL_RST_RTC   lvc330s080aaaaaaaaou
F6   o_PAL_SATA1_CONTROLLER0_R lvc330s080aaaaaaaaou
C19   o_PAL_TPCM_BIOS_DONE_R_N lvc180s080aaaaaaaaou
D19   o_PAL_TPCM_BMC_DONE_R_N lvc180s080aaaaaaaaou
Y18   o_PAL_TPCM_IRQ_R_L   lvc330s080aaaaaaaaou
P2   o_PAL_TPM_EN   lvc330s080aaaaaaaaou
R20   o_SPI1_BMC_WP_N_1V8  lvc330s120ahaaaaaaod
B12   o_SS_PAL_CLK_R   lvc330s080aaaaaaaaou
B13   o_SS_PAL_DATA_OUT_R  lvc330s080aaaaaaaaou
A12   o_SS_PAL_LOAD_N_R   lvc330s080aaaaaaaaou
A10   o_TPM_IO2_RST   lvc330s080aaaaaaaaou
G1   o_UART_SYS_TX_R   lvc330s080aaaaaaaaou
| Models and submodels in the file (9): lvc180axxxehaaaaaain (Input), lvc180s080aaaaaaaaou (Output), lvc330axxxefaaaaaain (Input), lvc330axxxgfaaaaaain (Input), lvc330s080aaaaaaaaou (Output), lvc330s080afaaaaaaod (I/O_open_drain), lvc330s080eaaaaaaaio (I/O), lvc330s120ahaaaaaaod (I/O_open_drain), lvc330s160afaaaaaaod (I/O_open_drain)
